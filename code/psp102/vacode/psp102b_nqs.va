//======================================================================================
//======================================================================================
// Filename: psp102b_nqs.va
//======================================================================================
//======================================================================================
//
//  (c) Copyright notice
//
//  Since 2012 until today, PSP has been co-developed by NXP Semiconductors and
//  Delft University of Technology. For this part of the model, each claim undivided
//  ownership and copyrights
//  Until and including 2011, PSP has been co-developed by NXP Semiconductors and
//  Arizona State University. For this part of the model, NXP Semiconductors claims
//  undivided ownership and copyrights.
//
//
//  Version: 102.5.0, December 2013
//
//======================================================================================
//======================================================================================
//
// Further information can be found in the file releasenotesPSP102.txt
//

`include "disciplines.vams"

`define NQSmodel true

`define Binning true

`include "Common102_macrodefs.include"

`include "JUNCAP200_macrodefs.include"

`include "PSP102_macrodefs.include"

// Note: some verilog-A compilers have problems handling the ddx-operator,
// which occurs in definition of OP-output variables. If the line below is
// commented out, all OP-output variables using the ddx-operator are skipped.
`define OPderiv

/////////////////////////////////////////////////////////////////////////////
//
//  PSP global model code (binning)
//
/////////////////////////////////////////////////////////////////////////////

`include "PSP102_nqs_macrodefs.include"

module PSPNQS102BVA(D, G, S, B);

`include "PSP102_module.include"

endmodule
