// ********************************************************
// **** BSIM6.0 released by Yogesh Singh Chauhan on 05/05/2013 ****/
// ********************************************************
//
// ********************************************************
// * Copyright 2013 Regents of the University of California.
// * All rights reserved.
// *
// * Project Director: Prof. Chenming Hu.
// * Authors: Yogesh Singh Chauhan, M. A. Karim
// *          Sriramkumar Venugopalan, Harshit Agarwal, Darsen Lu,
// *          Ali Niknejad, Chenming Hu
// ********************************************************
// ********************************************************
// *   NONDISCLOSURE STATEMENT
// Software is distributed as is, completely without warranty or service
// support. The University of California and its employees are not liable
// for the condition or performance of the software.
// The University of California owns the copyright and grants users a perpetual,
// irrevocable, worldwide, non-exclusive, royalty-free license with
// respect to the software as set forth below.
// The University of California hereby disclaims all implied warranties.
// The University of California grants the users the right to modify, copy,
// and redistribute the software and documentation, both within the user's
// organization and externally, subject to the following restrictions
// 1. The users agree not to charge for the University of California code
// itself but may charge for additions, extensions, or support.
// 2. In any product based on the software, the users agree to acknowledge
// the University of California that developed the software. This
// acknowledgment shall appear in the product documentation.
// 3. The users agree to obey all U.S. Government restrictions governing
// redistribution or export of the software.
// 4. The users agree to reproduce any copyright notice which appears on
// the software on any copy or modification of such made available
// to others
// Agreed to on __May 05, 2013_________________
// By: ___University of California, Berkeley____
//     ___Chenming Hu_____________________
//     ___Professor in Graduate School _______
// ********************************************************

// ********************************************************
// *  BSIM Bulk MOSFET Model Equations (Verilog-A)
// ********************************************************
`include "constants.vams"
`include "disciplines.vams"

// Disable strobe for improved performance speed
//`define DISABLE_STROBE    //To Use DISABLE_STROBE, Activate it here. Used Only at GEOMOD and RGEOMOD
`ifdef DISABLE_STROBE
    `define STROBE(X)
    `define STROBE2(X,Y)
`else
    `define STROBE(X) $strobe(X)
    `define STROBE2(X,Y) $strobe(X,Y)
`endif

// Not all Verilog-A compilers are able to properly collapse
// internal nodes  by shorting branches. To ensure minimal node
// count, comment out the following lines:
`define __RDSMOD__
`define __TNOISW__
`define __RGATEMOD__
`define __RBODYMOD__

// Normalized pinch-off voltage including PD
`define PO_psip(vg_vfb,gamma,DPD,phif,psip) \
    T1 = 1.0 + DPD; \
    vgfbPD = vg_vfb/T1; \
    gammaPD = gamma/T1; \
    T8 = phif + gammaPD*sqrt(phif); \
    if (vgfbPD > T8) begin \
        T1 = 0.5 * gammaPD; \
        T2 = sqrt(vgfbPD - 1.0 + T1*T1) - T1; \
        psip = T2*T2 + 1.0; \
    end else begin \
        T1 = 0.5*vgfbPD - 3.0*(1.0 + gammaPD/`M_SQRT2); \
        T2 = T1 + sqrt(T1*T1 + 6.0*vgfbPD); \
        if (vgfbPD < 0.0) begin \
            T3 = (vgfbPD - T2) / gammaPD; \
            psip = -ln(1.0 - T2 + T3*T3); \
        end else begin \
            T3 = exp(-T2); \
            T1 = 0.5 * gammaPD; \
            T2 = sqrt(vgfbPD - 1.0 + T3 + T1*T1) - T1; \
            psip = T2*T2 + 1.0 - T3; \
        end \
    end \

// BSIMv6's normalized charge-voltage relationship
`define BSIM_q(psip,phib,vch,gam,q) \
    T8 = 0.5*( psip+1.0 + sqrt((psip-1.0)*(psip-1.0) + 0.25*2*2 ) ); \
    sqrtpsip = sqrt(T8); \
    T9 = 1.0+ gam/(2.0*sqrtpsip); \
    T0 = ( 1.0+ (gam/(2.0*sqrtpsip)) )/gam; \
    T1 = psip - 2.0*phib -vch; \
    T2 = T1 - ln(4.0*T0*sqrtpsip); \
    T8 = 0.5*(T2 - 0.201491 - sqrt(T2 * (T2 + 0.402982) + 2.446562)); \
    sqrtpsisa = sqrtpsip; \
    if (T8 <= -68.0) begin \
        T4 = -100.0; \
        T5= 20.0; \
        if (T8 < T4 - 0.5 * T5) \
            T3 = exp(T4); \
        else begin \
            if (T8 > T4 + 0.5 * T5) \
                T3 = exp(T8); \
            else begin \
                T2 = (T8 - T4) / T5; \
                T6 = T2 * T2; \
                T3 = exp(T4 + T5 * ((5.0/64.0) + 0.5*T2 + T6*( (15.0/16.0) - T6*(1.25 - T6)))); \
            end \
        end \
        q = T3 * (1.0 + T1 - T8 -ln(2.0*T0*(T3*2.0*T0+2.0*sqrtpsisa))); \
    end else begin \
        T3 = exp(T8); \
        sqrtpsisainv = 1.0 / sqrtpsisa; \
        T4 = 2.0*T3 + ln(T3*2.0*T0*(T3*2.0*T0+2.0*sqrtpsisa)) - T1; \
        T5 = 2.0 + (1.0/T3) + (T0 - sqrtpsisainv)/(T0*T3 + sqrtpsisa); \
        T3 = T3 - T4/T5; \
        T4 = 2.0*T3 + ln(T3*2.0*T0*(T3*2.0*T0+2.0*sqrtpsisa)) - T1; \
        T5 = 2.0 + (1.0/T3) + (T0 - sqrtpsisainv)/(T0*T3 + sqrtpsisa); \
        T6 = ((T0 - sqrtpsisainv)/(T0*T3 + sqrtpsisa))*((T0 - sqrtpsisainv)/(T0*T3 + sqrtpsisa)); \
        T7 = -((1.0/T3)*(1.0/T3)) -(1.0/(sqrtpsisa*sqrtpsisa*sqrtpsisa*(T0*T3+sqrtpsisa))) - T6; \
        q = T3 - (T4/T5)*( 1.0 + T4*T7/(2.0*T5*T5)); \
    end \

// Smoothing function for (max of x, x0 with deltax)
`define Smooth(x,x0,deltax,xsmooth) \
    xsmooth = 0.5*( x+x0 + sqrt((x-x0)*(x-x0) + 0.25*deltax*deltax ) ); \
// Smoothing function for (max of x, x0 with deltax)
`define Smooth1(x,x0,deltax,xsmooth) \
    xsmooth = 0.5*( x+x0 + sqrt((x-x0)*(x-x0) + 0.25*deltax*deltax ) ) - 0.25*deltax; \
// Smoothing function for (min of x, x0 with deltax)
`define Smooth2(x,x0,deltax,xsmooth) \
    xsmooth = 0.5*( x+x0 - sqrt((x-x0)*(x-x0) + 0.25*deltax*deltax ) ) + 0.25*deltax; \

// Smoothing function for (min of x, x0 with deltax)
`define Min1(x,x0,deltax,xsmooth) \
    xsmooth = 0.5*( x+x0 - sqrt((x-x0)*(x-x0) + 0.25*deltax*deltax ) ) ; \

/*
 * These macros represent the subroutines to process the geometry dependent
 * parasitics for BSIM6, which calculates Ps, Pd, As, Ad, and Rs and Rd
 * for multi-fingers and various GEO and RGEO options.
 */
//Define GEOMOD and RGEOMOD in the Modelcard
`define BSIM6NumFingerDiff(nf, minSD, nuIntD, nuEndD, nuIntS, nuEndS) \
    if ((nf%2) != 0) begin \
        nuEndD = 1.0; \
        nuEndS = 1.0; \
        nuIntD = 2.0 * max((nf - 1.0) / 2.0, 0.0); \
        nuIntS = nuIntD; \
    end else begin \
        if (minSD == 1) begin \
            nuEndD = 2.0; \
            nuIntD = 2.0 * max((nf / 2.0 - 1.0), 0.0); \
            nuEndS = 0.0; \
            nuIntS = nf; \
        end else begin \
            nuEndD = 0.0; \
            nuIntD = nf; \
            nuEndS = 2.0; \
            nuIntS = 2.0 * max((nf / 2.0 - 1.0), 0.0); \
        end \
    end

`define BSIM6RdsEndIso(Weffcj, Rsh, DMCG, DMCI, DMDG, nuEnd, rgeo, TYPE, Rend) \
    if (TYPE == 1) begin \
        case (rgeo) \
            1, 2, 5: begin \
                if (nuEnd == 0.0) \
                    Rend = 0.0; \
                else \
                    Rend = Rsh * DMCG / (Weffcj * nuEnd); \
            end \
            3, 4, 6: begin \
                if ((DMCG + DMCI) == 0.0) \
                    `STROBE("(DMCG + DMCI) can not be equal to zero"); \
                if (nuEnd == 0.0) \
                    Rend = 0.0; \
                else \
                    Rend = Rsh * Weffcj / (3.0 * nuEnd * (DMCG + DMCI)); \
            end \
            default: begin \
                `STROBE2("Warning: (instance %M) Specified RGEO = %d not matched (BSIM6RdsEndIso), \
                Rend is set to zero.", rgeo); \
                Rend = 0.0; \
            end \
        endcase \
    end \
    else begin \
        case (rgeo) \
            1, 3, 7: begin \
                if (nuEnd == 0.0) \
                    Rend = 0.0; \
                else \
                    Rend = Rsh * DMCG / (Weffcj * nuEnd); \
            end \
            2, 4, 8: begin \
                if ((DMCG + DMCI) == 0.0) \
                    `STROBE("(DMCG + DMCI) can not be equal to zero"); \
                if (nuEnd == 0.0) \
                    Rend = 0.0; \
                else \
                    Rend = Rsh * Weffcj / (3.0 * nuEnd * (DMCG + DMCI)); \
            end \
            default: begin \
                `STROBE2("Warning: (instance %M) Specified RGEO=%d not matched (BSIM6RdsEndIso \
                type 2), Rend is set to zero.", rgeo); \
                Rend = 0.0; \
            end \
        endcase \
    end

`define BSIM6RdsEndSha(Weffcj, Rsh, DMCG, DMCI, DMDG, nuEnd, rgeo, TYPE, Rend) \
    begin \
        if (TYPE == 1) begin \
            case (rgeo) \
                1, 2, 5: begin \
                    if (nuEnd == 0.0) \
                        Rend = 0.0; \
                    else \
                        Rend = Rsh * DMCG / (Weffcj * nuEnd); \
                end \
                3, 4, 6: begin \
                    if (DMCG == 0.0) \
                        `STROBE("DMCG can not be equal to zero"); \
                    if (nuEnd == 0.0) \
                        Rend = 0.0; \
                    else \
                        Rend = Rsh * Weffcj / (6.0 * nuEnd * DMCG); \
                end \
                default: begin \
                    `STROBE2("Warning: (instance %M) Specified RGEO = %d not matched (BSIM6RdsEndSha), \
                    Rend is set to zero.", rgeo); \
                    Rend = 0.0; \
                end \
            endcase \
        end \
        else begin \
            case (rgeo) \
                1, 3, 7: begin \
                    if (nuEnd == 0.0) \
                        Rend = 0.0; \
                    else \
                        Rend = Rsh * DMCG / (Weffcj * nuEnd); \
                end \
                2, 4, 8: begin \
                    if (DMCG == 0.0) \
                        `STROBE("DMCG can not be equal to zero"); \
                    if (nuEnd == 0.0) \
                        Rend = 0.0; \
                    else \
                        Rend = Rsh * Weffcj / (6.0 * nuEnd * DMCG); \
                end \
                default: begin \
                    `STROBE2("Warning: (instance %M) Specified RGEO=%d not matched (BSIM6RdsEndSha \
                    type 2), Rend is set to zero.", rgeo); \
                    Rend = 0.0; \
                end \
            endcase \
        end \
    end

`define BSIM6RdseffGeo(nf, geo, rgeo, minSD, Weffcj, Rsh, DMCG, DMCI, DMDG, TYPE, Rtot) \
    begin \
        if (geo < 9) begin \
            `BSIM6NumFingerDiff(nf, minSD, nuIntD, nuEndD, nuIntS, nuEndS) \
            if (TYPE == 1) begin \
                if (nuIntS == 0.0) \
                    Rint = 0.0; \
                else \
                    Rint = Rsh * DMCG / ( Weffcj * nuIntS); \
            end \
            else begin \
                if (nuIntD == 0.0) \
                    Rint = 0.0; \
                else \
                    Rint = Rsh * DMCG / ( Weffcj * nuIntD); \
            end \
        end \
        case (geo) \
            0: begin \
                if (TYPE == 1) \
                    `BSIM6RdsEndIso(Weffcj, Rsh, DMCG, DMCI, DMDG, nuEndS, \
                rgeo, 1, Rend) \
                else \
                    `BSIM6RdsEndIso(Weffcj, Rsh, DMCG, DMCI, DMDG, nuEndD, \
                rgeo, 0, Rend) \
            end \
            1: begin \
                if (TYPE == 1) \
                    `BSIM6RdsEndIso(Weffcj, Rsh, DMCG, DMCI, DMDG, nuEndS, \
                rgeo, 1, Rend) \
                else \
                    `BSIM6RdsEndSha(Weffcj, Rsh, DMCG, DMCI, DMDG, nuEndD, \
                rgeo, 0, Rend) \
            end \
            2: begin \
                if (TYPE == 1) \
                    `BSIM6RdsEndSha(Weffcj, Rsh, DMCG, DMCI, DMDG, nuEndS, \
                rgeo, 1, Rend) \
                else \
                    `BSIM6RdsEndIso(Weffcj, Rsh, DMCG, DMCI, DMDG, nuEndD, \
                rgeo, 0, Rend) \
            end \
            3: begin \
                if (TYPE == 1) \
                    `BSIM6RdsEndSha(Weffcj, Rsh, DMCG, DMCI, DMDG, nuEndS, \
                rgeo, 1, Rend) \
                else \
                    `BSIM6RdsEndSha(Weffcj, Rsh, DMCG, DMCI, DMDG, nuEndD, \
                rgeo, 0, Rend) \
            end \
            4: begin \
                if (TYPE == 1) \
                    `BSIM6RdsEndIso(Weffcj, Rsh, DMCG, DMCI, DMDG, nuEndS, \
                rgeo, 1, Rend) \
                else \
                    Rend = Rsh * DMDG / Weffcj; \
            end \
            5: begin \
                if (TYPE == 1) \
                    `BSIM6RdsEndSha(Weffcj, Rsh, DMCG, DMCI, DMDG, nuEndS, \
                rgeo, 1, Rend) \
                else \
                    Rend = Rsh * DMDG / (Weffcj * nuEndD); \
            end \
            6: begin \
                if (TYPE == 1) \
                    Rend = Rsh * DMDG / Weffcj; \
                else \
                    `BSIM6RdsEndIso(Weffcj, Rsh, DMCG, DMCI, DMDG, nuEndD, \
                rgeo, 0, Rend) \
            end \
            7: begin \
                if (TYPE == 1) \
                    Rend = Rsh * DMDG / (Weffcj * nuEndS); \
                else \
                    `BSIM6RdsEndSha(Weffcj, Rsh, DMCG, DMCI, DMDG, nuEndD, \
                rgeo, 0, Rend) \
            end \
            8: begin \
                Rend = Rsh * DMDG / Weffcj; \
            end \
            9: begin /* all wide contacts assumed for geo = 9 and 10 */ \
                if (TYPE == 1) begin \
                    Rend = 0.5 * Rsh * DMCG / Weffcj; \
                    if (nf == 2.0) \
                        Rint = 0.0; \
                    else \
                        Rint = Rsh * DMCG / (Weffcj * (nf - 2.0)); \
                end \
                else begin \
                    Rend = 0.0; \
                    Rint = Rsh * DMCG / (Weffcj * nf); \
                end \
            end \
            10: begin \
                if (TYPE == 1) begin \
                    Rend = 0.0; \
                    Rint = Rsh * DMCG / (Weffcj * nf); \
                end \
                else begin \
                    Rend = 0.5 * Rsh * DMCG / Weffcj; \
                    if (nf == 2.0) \
                        Rint = 0.0; \
                    else \
                        Rint = Rsh * DMCG / (Weffcj * (nf - 2.0)); \
                end \
            end \
            default: begin \
                `STROBE2("Warning: (instance %M) Specified RGEO=%d not matched (BSIM6RdseffGeo \
                ), Rint is set to zero.", rgeo); \
                Rint = 0.0; \
            end \
        endcase \
        if (Rint <= 0.0) \
            Rtot = Rend; \
        else if (Rend <= 0.0) \
            Rtot = Rint; \
        else \
            Rtot = Rint * Rend / (Rint + Rend); \
        if (Rtot==0.0) \
            `STROBE("Warning: (instance %M) Zero resistance returned from RdseffGeo"); \
    end

// Numerical Constants
`define EXPL_THRESHOLD 80.0
`define MAX_EXPL 5.540622384e+34
`define MIN_EXPL 1.804851387e-35
`define N_MINLOG    1.0e-38
`define DELTA_1 0.02
`define Oneby3      0.33333333333333333
`define REFTEMP (300.15) /* 27 degrees C */

//Physical Constants
`define ntype 1
`define ptype -1
`define q    1.60219e-19
`define EPS0 8.85418e-12
`define KboQ 8.617087e-5 // Joule / degree

module bsim6(d, g, s, b);
inout d, g, s, b;
electrical d, g, s, b;

`ifdef __RDSMOD__
    electrical di, si;
`endif

`ifdef __RGATEMOD__
    electrical gi, gm;
`endif
`ifdef __RBODYMOD__
    electrical bi, sbulk, dbulk;
`endif

// Node definitions
`ifdef __RDSMOD__
    `define IntrinsicDrain di
    `define IntrinsicSource si
`else
    `define IntrinsicDrain d
    `define IntrinsicSource s
`endif

`ifdef __RGATEMOD__
    `define IntrinsicGate gi
    `define GateEdgeNode gm
`else
    `define IntrinsicGate g
    `define GateEdgeNode g
`endif

`ifdef __RBODYMOD__
    `define IntrinsicBody bi
`else
    `define IntrinsicBody b
`endif

// Extra internal nodes and branches (TNOIMOD=1) for correlated drain and gate noise
`ifdef __TNOISW__
    electrical N1, N2;
    branch (N1) NI;
    branch (N1) NR;
    branch (N1) NC;
`endif

// Clamped exponential function
analog function real lexp;
    input x;
    real x;
    begin
        if (x > `EXPL_THRESHOLD) begin
            lexp = `MAX_EXPL * (1.0+(x)-`EXPL_THRESHOLD);
        end else if (x < -`EXPL_THRESHOLD) begin
            lexp = `MIN_EXPL;
        end else begin
            lexp = exp(x);
        end
    end
endfunction

// Clamped log function
analog function real lln;
    input x;
    real x;
    begin
        lln = ln(max(x , `N_MINLOG));
    end
endfunction

// Hyperbolic smoothing function
analog function real hypsmooth;
    input x , c;
    real x , c;
    begin
        hypsmooth = 0.5 * (x + sqrt(x*x + 4.0*c*c));
    end
endfunction

/************************/
/*  Model Parameters    */
/************************/
parameter integer TYPE      = `ntype    from [`ptype:`ntype] exclude 0;
parameter integer GEOMOD    = 0         from [0:10];// Geo dependent parasitics model
parameter integer RGEOMOD   = 0     from [0:8]; // Geometry-dependent source/drain resistance
//  0: RSH-based, 1: Holistic
parameter integer COVMOD    = 0     from [0:1]; // 0: Use Bias-independent Overlap Capacitances
// 1: Use Bias-dependent Overlap Capacitances
parameter integer RDSMOD    = 0         from [0:1]; // 0: Internal s/d resistance model
// 1: External s/d resistance model
parameter integer GIDLMOD   = 0     from [0:1]; // 0: Turn off GIDL Current
// 1: Turn on GIDL Current
parameter integer RGATEMOD  = 0     from [0:3]; // Gate resistance model selector
parameter integer RBODYMOD  = 0     from [0:2]; // Distributed body R model
parameter integer IGCMOD    = 0     from [0:1]; // 0: Turn off Igc, Igs and Igd
// 1: Turn on Igc, Igs and Igd
parameter integer IGBMOD    = 0     from [0:1]; // 0: Turn off Igb
// 1: Turn on Igb
parameter integer TNOIMOD   = 0     from [0:1]; // Thermal noise model selector

// *************************
//   Device Parameters
// *************************
parameter real L        = 10u   from (0:inf);   // units are m
parameter real LLONG        = 10u   from (0:inf);   // L of extracted Long channel device - units are m
parameter real XL       = 0.0;          // L offset for channel length due to mask/etch effect
parameter real W        = 10u   from (0:inf);   // Total Width including fingers (units are m)
parameter real WWIDE        = 10u   from (0:inf);   // W of extracted Wide channel device - units are m
parameter real XW       = 0.0;                  // W offset for channel length due to mask/etch effect
parameter real LINT     = 0.0;                  // delta L for IV
parameter real LL       = 0.0;
parameter real LW       = 0.0;
parameter real LWL      = 0.0;
parameter real LLN      = 1.0;
parameter real LWN      = 1.0;
parameter real WINT     = 0.0;                  // delta W for IV
parameter real WL       = 0.0;
parameter real WW       = 0.0;
parameter real WWL      = 0.0;
parameter real WLN      = 1.0;
parameter real WWN      = 1.0;
parameter real DLC      = 0.0;                  // delta L for CV
parameter real LLC      = 0.0;
parameter real LWC      = 0.0;
parameter real LWLC     = 0.0;
parameter real DWC      = 0.0;                  // delta W for CV
parameter real WLC      = 0.0;
parameter real WWC      = 0.0;
parameter real WWLC     = 0.0;
parameter real TOXE     = 3.0e-9 from (0:inf);  // Effective gate dielectric thickness relative to SiO2, m
parameter real TOXP     = TOXE;                 // Physical gate dielectric thickness, m
// If not given, TOXP is calculated from TOXE and DTOX
parameter real DTOX     = 0.0;                  // Difference between effective dielectric thickness
// and physical thickness
parameter integer NF    = 1     from [1:inf);   // number of fingers
parameter real NDEP     = 1e24;                 // Channel Doping Concentration (m^-3) for IV
parameter real NDEPL1   = 0.0;                  // Length dependence coefficient of NDEP
parameter real NDEPLEXP1 = 1.0  from (0:inf);           // Length dependence exponent coefficient of NDEP
parameter real NDEPL2   = 0.0;                  // Length dependence of NDEP - For Short Channel Devices
parameter real NDEPLEXP2 = 2.0  from (0:inf);           // Length dependence exponent coefficient of NDEP
parameter real NDEPW    = 0.0;                  // Width dependence coefficient of NDEP
parameter real NDEPWEXP = 1.0   from (0:inf);           // Width dependence exponent coefficient of NDEP
parameter real NDEPWL   = 0.0;                  // Width-Length dependence coefficient of NDEP
parameter real NDEPWLEXP = 1.0  from (0:inf);           // Width-Length dependence exponent coefficient of NDEP
parameter real LNDEP    = 0.0;
parameter real WNDEP    = 0.0;
parameter real PNDEP    = 0.0;

parameter real NDEPCV   = NDEP;                 // Channel Doping Concentration (m^-3) for CV
parameter real NDEPCVL1 = NDEPL1;               // Length dependence coefficient of NDEPCV
parameter real NDEPCVLEXP1 = NDEPLEXP1  from (0:inf);       // Length dependence exponent coefficient of NDEPCV
parameter real NDEPCVL2 = NDEPL2;               // Length dependence coefficient of NDEPCV - For Short Channel Devices
parameter real NDEPCVLEXP2 = NDEPLEXP2  from (0:inf);       // Length dependence exponent coefficient of NDEPCV
parameter real NDEPCVW  = NDEPW;                // Width dependence coefficient of NDEPCV
parameter real NDEPCVWEXP = NDEPWEXP    from (0:inf);       // Width dependence exponent coefficient of NDEPCV
parameter real NDEPCVWL = NDEPWL;               // Width-Length dependence coefficient of NDEPCV
parameter real NDEPCVWLEXP = NDEPWLEXP  from (0:inf);       // Width-Length dependence exponent coefficient of NDEPCV
parameter real LNDEPCV  = LNDEP;
parameter real WNDEPCV  = WNDEP;
parameter real PNDEPCV  = PNDEP;

parameter real NGATE    = 5e25;                 // Gate Doping Concentration (m^-3)
parameter real LNGATE   = 0.0;
parameter real WNGATE   = 0.0;
parameter real PNGATE   = 0.0;

parameter real EASUB    = 4.05;                 // Electron affinity of substrate, eV
parameter real NI0SUB   = 1.1e16;               // Intrinsic carrier concentration of the substrate at 300.15K ( m^-3)
parameter real BG0SUB   = 1.17;                 // Band gap of substrate at 300.15K, eV
parameter real EPSRSUB  = 11.9;                 // Relative dielectric constant of the channel material
parameter real EPSROX   = 3.9 from (0:inf);     // Relative dielectric constant of the gate dielectric
parameter real XJ       = 1.5e-7;               // S/D junction depth
parameter real LXJ      = 0.0;
parameter real WXJ      = 0.0;
parameter real PXJ      = 0.0;
parameter real VFB      = -1.0;                 // Flat band voltage for IV
parameter real LVFB     = 0.0;
parameter real WVFB     = 0.0;
parameter real PVFB     = 0.0;

parameter real VFBCV    = VFB;                  // Flat band voltage for CV
parameter real LVFBCV   = LVFB;
parameter real WVFBCV   = WVFB;
parameter real PVFBCV   = PVFB;
parameter real VFBCVL   = 0.0;                  // Length dependence coefficient of VFBCV
parameter real VFBCVLEXP = 1.0  from (0:inf);           // Length dependence exponent coefficient of VFBCV
parameter real VFBCVW   = 0.0;                  // Width dependence coefficient of VFBCV
parameter real VFBCVWEXP = 1.0  from (0:inf);           // Width dependence exponent coefficient of VFBCV
parameter real VFBCVWL  = 0.0;                  // Width-Length dependence coefficient of VFBCV
parameter real VFBCVWLEXP = 1.0 from (0:inf);           // Width-Length dependence coefficient of VFBCV

//Diode parameters
parameter integer PERMOD    = 1 from [0:1];     // Whether PS/PD (when given) include gate-edge perimeter
parameter real AS       = 0.0 from [0:inf);     // Source to Substrate Junction Area
parameter real AD       = 0.0 from [0:inf);     // Drain to Substrate Junction Area
parameter real PS       = 0.0 from [0:inf);     // Source to Substrate Junction Perimeter
parameter real PD       = 0.0 from [0:inf);     // Drain to Substrate Junction Perimeter
parameter real DWJ      = DWC;                  // delta W for S/D junctions

// Rd, Rs related Parameter
parameter real VFBSDOFF = 0.0;
parameter real NRS      = 1.0 from [0:inf);     // Number of squares in source
parameter real NRD      = 1.0 from [0:inf);     // Number of squares in drain
parameter integer MINZ  = 0   from [0:1];       // Minimize either D or S

// Short Channel Effects
parameter real NSD      = 1e26;                 // S/D Doping Concentration (m^-3)
parameter real LNSD     = 0.0;
parameter real WNSD     = 0.0;
parameter real PNSD     = 0.0;

parameter real DVTP0    = 0.0;              // DITS
parameter real LDVTP0   = 0;
parameter real WDVTP0   = 0;
parameter real PDVTP0   = 0;
parameter real DVTP1    = 0.0;                  // DITS
parameter real LDVTP1   = 0;
parameter real WDVTP1   = 0;
parameter real PDVTP1   = 0;
parameter real DVTP2    = 0.0;                  // DITS
parameter real LDVTP2   = 0;
parameter real WDVTP2   = 0;
parameter real PDVTP2   = 0;
parameter real DVTP3    = 0.0;                  // DITS
parameter real LDVTP3   = 0;
parameter real WDVTP3   = 0;
parameter real PDVTP3   = 0;
parameter real DVTP4    = 0.0;                  // DITS
parameter real LDVTP4   = 0;
parameter real WDVTP4   = 0;
parameter real PDVTP4   = 0;
parameter real DVTP5    = 0.0;                  // DITS
parameter real LDVTP5   = 0;
parameter real WDVTP5   = 0;
parameter real PDVTP5   = 0;

parameter real PHIN     = 0.045;                // Nonuniform vertical doping effect on surface potential, V
parameter real LPHIN    = 0.0;
parameter real WPHIN    = 0.0;
parameter real PPHIN    = 0.0;

parameter real ETA0     = 0.08;                 // DIBL coefficient
parameter real LETA0    = 0.0;
parameter real WETA0    = 0.0;
parameter real PETA0    = 0.0;
parameter real DSUB     = 1.0;                  // Length scaling exponent for DIBL
parameter real ETAB     = -0.07;                // Body bias coefficient for subthreshold DIBL effect
parameter real ETABEXP  = 1.0   from (0:inf);           // Exponent coefficient of ETAB
parameter real LETAB    = 0.0;
parameter real WETAB    = 0.0;
parameter real PETAB    = 0.0;

parameter real K2   = 0.0   from (-inf:0];          // Vth shift due to Vertical Non-uniform doping
parameter real K2L  = 0.0;                  // Length dependence coefficient of K2
parameter real K2LEXP   = 1.0   from (0:inf);           // Length dependence exponent coefficient of K2
parameter real K2W  = 0.0;                  // Width dependence coefficient of K2
parameter real K2WEXP   = 1.0   from (0:inf);           // Width dependence exponent coefficient of K2
parameter real K2WL     = 0.0;                  // Width-Length dependence coefficient of K2
parameter real K2WLEXP  = 1.0   from (0:inf);           // Width-Length dependence exponent coefficient of K2
parameter real LK2  = 0.0;
parameter real WK2  = 0.0;
parameter real PK2  = 0.0;

// Quantum Mechanical Effects
parameter real ADOS     = 0.0   from [0:inf);   // Quantum mechanical effect prefactor cum switch in inversion
parameter real BDOS     = 1.0   from [0:inf);   // Charge centroid parameter - slope of CV curve under QME in inversion
parameter real QM0      = 1.0e-3 from (0:inf);  // Charge centroid parameter - starting point for QME in inversion
parameter real ETAQM    = 0.54  from [0:inf);   // Bulk charge coefficient for charge centroid in inversion

//Subthreshold Swing Factor
parameter real CIT  = 0.0   from [0:inf);   // parameter for interface trap
parameter real LCIT     = 0.0;
parameter real WCIT     = 0.0;
parameter real PCIT     = 0.0;

parameter real NFACTOR      = 0.0   from [0:inf);   // Sub-threshold slope factor
parameter real NFACTORL     = 0.0;          // Length dependence coefficient of NFACTOR
parameter real NFACTORLEXP  = 1.0   from (0:inf);   // Length dependence exponent coefficient of NFACTOR
parameter real NFACTORW     = 0.0;          // Width dependence coefficient of NFACTOR
parameter real NFACTORWEXP  = 1.0   from (0:inf);   // Width dependence exponent coefficient of NFACTOR
parameter real NFACTORWL    = 0.0;          // Width-Length dependence coefficient of NFACTOR
parameter real NFACTORWLEXP     = 1.0   from (0:inf);   // Width-Length dependence exponent coefficient of NFACTOR
parameter real LNFACTOR     = 0.0;
parameter real WNFACTOR     = 0.0;
parameter real PNFACTOR     = 0.0;

parameter real CDSCD    = 1e-9  from [0:inf);       // drain-bias sensitivity of sub-threshold slope
parameter real CDSCDL   = 0.0;              // Length dependence coefficient of CDSCD
parameter real CDSCDLEXP = 1.0  from (0:inf);       // Length dependence exponent coefficient of CDSCD
parameter real LCDSCD   = 0.0;
parameter real WCDSCD   = 0.0;
parameter real PCDSCD   = 0.0;
parameter real CDSCB    = 0.0   from [0:inf);       // body-bias sensitivity of sub-threshold slope
parameter real CDSCBL   = 0.0;              // Length dependence coefficient of CDSCB
parameter real CDSCBLEXP = 1.0  from (0:inf);       // Length dependence exponent coefficient of CDSCB
parameter real LCDSCB   = 0.0;
parameter real WCDSCB   = 0.0;
parameter real PCDSCB   = 0.0;

//Drain Saturation Voltage
parameter real VSAT     = 1e5;                  // Saturation Velocity m/s
parameter real LVSAT        = 0.0;
parameter real WVSAT        = 0.0;
parameter real PVSAT        = 0.0;
parameter real VSATL        = 0.0;                  // Length dependence coefficient of of VSAT
parameter real VSATLEXP     = 1.0   from (0:inf);           // Length dependence exponent coefficient of VSAT
parameter real VSATW        = 0.0;                  // Width dependence coefficient of of VSAT
parameter real VSATWEXP     = 1.0   from (0:inf);           // Width dependence exponent coefficient of of VSAT
parameter real VSATWL       = 0.0;                  // Width-Length dependence coefficient of of VSAT
parameter real VSATWLEXP    = 1.0   from (0:inf);           // Width-Length dependence exponent coefficient of of VSAT
parameter real DELTA        = 0.125;                // Smoothing function factor for Vdsat
parameter real LDELTA       = 0.0;
parameter real WDELTA       = 0.0;
parameter real PDELTA       = 0.0;
parameter real DELTAL       = 0.0;                  // Length dependence coefficient of DELTA
parameter real DELTALEXP    = 1.0   from (0:inf);           // Length dependence exponent coefficient of DELTA

parameter real VSATCV       = VSAT;                 // VSAT parameter for CV
parameter real LVSATCV      = LVSAT;
parameter real WVSATCV      = WVSAT;
parameter real PVSATCV      = PVSAT;
parameter real VSATCVL      = VSATL;
parameter real VSATCVLEXP   = VSATLEXP  from (0:inf);
parameter real VSATCVW      = VSATW;
parameter real VSATCVWEXP   = VSATWEXP  from (0:inf);
parameter real VSATCVWL     = VSATWL;
parameter real VSATCVWLEXP  = VSATWLEXP from (0:inf);

// Mobility Degradation
parameter real U0       = 67.0e-3;          // units are m2/Vs
parameter real U0L      = 0.0;              // Length dependence coefficient of U0L
parameter real U0LEXP       = 1.0   from (0:inf);       // Length dependence exponent coefficient of U0L
parameter real LU0      = 0.0;
parameter real WU0      = 0.0;
parameter real PU0      = 0.0;

parameter real ETAMOB       = 1.0;              // Effective field parameter (should be kept close to 1)

parameter real UA       = 0.001;            // Mobility reduction coefficient
parameter real UAL      = 0.0;              // Length dependence coefficient of  UA
parameter real UALEXP       = 1.0   from (0:inf);       // Length dependence exponent coefficient of  UA
parameter real UAW      = 0.0;              // Width dependence coefficient of UA
parameter real UAWEXP       = 1.0   from (0:inf);       // Width dependence exponent coefficient of UA
parameter real UAWL     = 0.0;              // Width-Length dependence coefficient of UA
parameter real UAWLEXP      = 1.0   from (0:inf);       // Width-Length dependence coefficient of UA
parameter real LUA      = 0.0;
parameter real WUA      = 0.0;
parameter real PUA      = 0.0;

parameter real EU       = 1.5;              // Mobility reduction exponent
parameter real LEU      = 0.0;
parameter real WEU      = 0.0;
parameter real PEU      = 0.0;
parameter real EUL      = 0.0;                  // Length dependence coefficient of EU
parameter real EULEXP       = 1.0   from (0:inf);           // Length dependence exponent coefficient of EU
parameter real EUW      = 0.0;                  // Width dependence coefficient of EU
parameter real EUWEXP       = 1.0   from (0:inf);           // Width dependence exponent coefficient of EU
parameter real EUWL     = 0.0;                  // Width-Length dependence coefficient of EU
parameter real EUWLEXP      = 1.0   from (0:inf);           // Width-Length dependence coefficient of EU

parameter real UD       = 0.001;                // Coulombic scattering parameter
parameter real UDL      = 0.0;                  // Length dependence coefficient of UD
parameter real UDLEXP       = 1.0   from (0:inf);           // Length dependence exponent coefficient of UD
parameter real LUD      = 0.0;
parameter real WUD      = 0.0;
parameter real PUD      = 0.0;

parameter real UCS      = 2.0;                  // Coulombic scattering parameter
parameter real LUCS     = 0.0;
parameter real WUCS     = 0.0;
parameter real PUCS     = 0.0;

parameter real UC       = 0.0   from [0:inf);           // Mobility reduction with body bias
parameter real UCL      = 0.0;                  // Length dependence coefficient of UC
parameter real UCLEXP       = 1.0   from (0:inf);           // Length dependence exponent coefficient of UC
parameter real UCW      = 0.0;                  // Width dependence coefficient of UC
parameter real UCWEXP       = 1.0   from (0:inf);           // Width dependence exponent coefficient of UC
parameter real UCWL     = 0.0;                  // Width-Length dependence coefficient of UC
parameter real UCWLEXP      = 1.0   from (0:inf);           // Width-Length dependence exponent coefficient of UC
parameter real LUC      = 0.0;
parameter real WUC      = 0.0;
parameter real PUC      = 0.0;

// Channel Length Modulation
parameter real PCLM     = 0.0 from [0:inf);     // CLM prefactor
parameter real PCLML        = 0.0;              // Length dependence coefficient of PCLM
parameter real PCLMLEXP     = 1.0 from (0:inf);     // Length dependence exponent coefficient of PCLM
parameter real LPCLM        = 0.0;
parameter real WPCLM        = 0.0;
parameter real PPCLM        = 0.0;

parameter real PCLMG        = 0.0;              // CLM prefactor gate voltage dependence

parameter real PCLMCV       = PCLM from [0:inf);        // CLM parameter for CV
parameter real PCLMCVL      = PCLML;
parameter real PCLMCVLEXP   = PCLMLEXP from (0:inf);
parameter real LPCLMCV      = LPCLM;
parameter real WPCLMCV      = WPCLM;
parameter real PPCLMCV      = PPCLM;

parameter real PSCBE1   = 4.24e8;               // Substrate current body-effect coeff
parameter real LPSCBE1  = 0.0;
parameter real WPSCBE1  = 0.0;
parameter real PPSCBE1  = 0.0;
parameter real PSCBE2   = 1.0e-8;               // Substrate current body-effect coeff
parameter real LPSCBE2  = 0.0;
parameter real WPSCBE2  = 0.0;
parameter real PPSCBE2  = 0.0;

parameter real PDITS    = 0.0 from [0:inf);     // Coefficient for drain-induced Vth shifts
parameter real LPDITS   = 0.0;
parameter real WPDITS   = 0.0;
parameter real PPDITS   = 0.0;
parameter real PDITSL   = 0.0 from [0:inf);     // L dep of drain-induced Vth shifts
parameter real PDITSD   = 0.0;                  // Vds dep of drain-induced Vth shifts
parameter real LPDITSD  = 0.0;
parameter real WPDITSD  = 0.0;
parameter real PPDITSD  = 0.0;

// S/D Series Resistance
parameter real RSH  = 0.0 from [0:inf);     // Source-drain sheet resistance [Ohm]
parameter real PRWG     = 1.0;                  // gate bias dependence of S/D extension resistance, V-1
parameter real LPRWG    = 0.0;
parameter real WPRWG    = 0.0;
parameter real PPRWG    = 0.0;
parameter real PRWB     = 0.0;                  // Body bias dependence of resistance
parameter real LPRWB    = 0.0;
parameter real WPRWB    = 0.0;
parameter real PPRWB    = 0.0;
parameter real PRWBL    = 0.0;                  // Length dependence coefficient of PPRWB
parameter real PRWBLEXP = 1.0   from (0:inf);           // Length dependence exponent coefficient of PPRWB
parameter real WR   = 1.0;                  // W dependence parameter of S/D extension resistance
parameter real LWR  = 0.0;
parameter real WWR  = 0.0;
parameter real PWR  = 0.0;

parameter real RSWMIN   = 0.0;                  // Source Resistance per unit width at high Vgs (RDSMOD=1)
parameter real LRSWMIN  = 0.0;
parameter real WRSWMIN  = 0.0;
parameter real PRSWMIN  = 0.0;
parameter real RSW  = 10.0;                 // zero bias Source Resistance (RDSMOD=1)
parameter real LRSW     = 0.0;
parameter real WRSW     = 0.0;
parameter real PRSW     = 0.0;
parameter real RSWL     = 0.0;                  // Geometrical scaling of RSW (RDSMOD=1)
parameter real RSWLEXP  = 1.0   from (0:inf);           // Geometrical scaling of RSW (RDSMOD=1)

parameter real RDWMIN   = RSWMIN;               // Drain Resistance per unit width at high Vgs (RDSMOD=1)
parameter real LRDWMIN  = LRSWMIN;
parameter real WRDWMIN  = WRSWMIN;
parameter real PRDWMIN  = PRSWMIN;
parameter real RDW  = RSW;                  // zero bias Drain Resistance (RDSMOD=1)
parameter real LRDW     = LRSW;
parameter real WRDW     = WRSW;
parameter real PRDW     = PRSW;
parameter real RDWL     = RSWL;                 // Geometrical scaling of RDW (RDSMOD=1)
parameter real RDWLEXP  = RSWLEXP   from (0:inf);       // Geometrical scaling of RDW (RDSMOD=1)

parameter real RDSWMIN  = 0.0;                  // S/D Resistance per unit width at high Vgs (RDSMOD=0)
parameter real LRDSWMIN = 0.0;
parameter real WRDSWMIN = 0.0;
parameter real PRDSWMIN = 0.0;
parameter real RDSW     = 20.0;                 // zero bias Resistance (RDSMOD=0)
parameter real RDSWL    = 0.0;                  // Geometrical scaling of RDSW (RDSMOD=0)
parameter real RDSWLEXP = 1.0   from (0:inf);           // Geometrical scaling of RDSW (RDSMOD=0)
parameter real LRDSW    = 0.0;
parameter real WRDSW    = 0.0;
parameter real PRDSW    = 0.0;

// Velocity Saturation
parameter real PSAT     = 1.0 from (0:inf);     // Gmsat variation with gate bias
parameter real LPSAT    = 0.0;
parameter real WPSAT    = 0.0;
parameter real PPSAT    = 0.0;
parameter real PSATL    = 0.0;
parameter real PSATLEXP = 1.0   from (0:inf);
parameter real PSATB    = 0.0;                  // Body bias effect on Idsat
parameter real PSATX    = 1.0 from (0:inf);
parameter real PTWG     = 0.0;                  // Idsat variation with gate bias
parameter real LPTWG    = 0.0;
parameter real WPTWG    = 0.0;
parameter real PPTWG    = 0.0;
parameter real PTWGL    = 0.0;                  // Length dependence coefficient of PTWG
parameter real PTWGLEXP = 1.0   from (0:inf);           // Length dependence exponent coefficient of PTWG

// Output Conductance
parameter real PDIBLC   = 0.0;                  // parameter for DIBL effect on Rout
parameter real PDIBLCL  = 0.0;                  // Length dependence coefficient of PDIBLC
parameter real PDIBLCLEXP = 1.0 from (0:inf);           // Length dependence exponent coefficient of PDIBLC
parameter real LPDIBLC  = 0.0;
parameter real WPDIBLC  = 0.0;
parameter real PPDIBLC  = 0.0;

parameter real PDIBLCB  = 0.0;                  // parameter for DIBL effect on Rout
parameter real LPDIBLCB = 0.0;
parameter real WPDIBLCB = 0.0;
parameter real PPDIBLCB = 0.0;

parameter real PVAG     = 1.0;                  // Vg dependence of early voltage
parameter real LPVAG    = 0.0;
parameter real WPVAG    = 0.0;
parameter real PPVAG    = 0.0;

parameter real FPROUT   = 0.0;
parameter real FPROUTL  = 0.0;                  // Length dependence coefficient of FPROUT
parameter real FPROUTLEXP = 1.0 from (0:inf);           // Length dependence exponent coefficient of FPROUT
parameter real LFPROUT  = 0.0;
parameter real WFPROUT  = 0.0;
parameter real PFPROUT  = 0.0;

// Impact Ionization Current
parameter real ALPHA0   = 0.0;                  // first parameter of Iii, m/V
parameter real ALPHA0L  = 0.0;                  // Length dependence coefficient of ALPHA0
parameter real ALPHA0LEXP = 1.0 from (0:inf);           // Length dependence exponent coefficient of ALPHA0
parameter real LALPHA0  = 0.0;
parameter real WALPHA0  = 0.0;
parameter real PALPHA0  = 0.0;

parameter real BETA0    = 0.0;                  // Vds dependent parameter of Iii, 1/V
parameter real LBETA0   = 0.0;
parameter real WBETA0   = 0.0;
parameter real PBETA0   = 0.0;

//Gate Dielectric Tunneling Current Model Parameters
parameter real AIGBACC = 1.36e-2;               // Parameter for Igb
parameter real BIGBACC = 1.71e-3;               // Parameter for Igb
parameter real CIGBACC = 0.075;                 // Parameter for Igb
parameter real NIGBACC = 1.0;                   // Parameter for Igbacc slope
parameter real AIGBINV = 1.11e-2;               // Parameter for Igb
parameter real BIGBINV = 9.49e-4;               // Parameter for Igb
parameter real CIGBINV = 0.006;                 // Parameter for Igb
parameter real EIGBINV = 1.1;                   // Parm for the Si bandgap for Igbinv [V]
parameter real NIGBINV = 3.0;                   // Parameter for Igbinv slope
parameter real AIGC = (TYPE == `ntype) ? 1.36e-2 : 9.8e-3;      // Parameter for Igc
parameter real BIGC = (TYPE == `ntype) ? 1.71e-3 : 7.59e-4;         // Parameter for Igc
parameter real CIGC = (TYPE == `ntype) ? 0.075 : 0.03;          // Parameter for Igc
parameter real AIGS = (TYPE == `ntype) ? 1.36e-2 : 9.8e-3;      // Parameter for Igs d
parameter real BIGS = (TYPE == `ntype) ? 1.71e-3 : 7.59e-4;         // Parameter for Igs d
parameter real CIGS = (TYPE == `ntype) ? 0.075 : 0.03;          // Parameter for Igs d
parameter real AIGD = (TYPE == `ntype) ? 1.36e-2 : 9.8e-3;      // Parameter for Igs d
parameter real BIGD = (TYPE == `ntype) ? 1.71e-3 : 7.59e-4;         // Parameter for Igs d
parameter real CIGD = (TYPE == `ntype) ? 0.075 : 0.03;          // Parameter for Igs d
parameter real DLCIG  = LINT;                   // Delta L for Ig model [m]
parameter real DLCIGD = DLCIG;                  // Delta L for Ig model [m]
parameter real POXEDGE = 1.0;                   // Factor for the gate edge Tox
parameter real NTOX = 1.0;                      // Exponent for Tox ratio
parameter real TOXREF = 3.0e-9 from (0:inf);            // Target tox value [m]
parameter real PIGCD = 1.0 from [-50:50];           // Igc, S/D partition parameter

parameter real AIGCL = 0.0;                     // Length dependence coefficient of AIGC
parameter real AIGCW = 0.0;                     // Width dependence coefficient of AIGC
parameter real AIGSL = 0.0;                     // Length dependence coefficient of AIGS
parameter real AIGSW = 0.0;                     // Width dependence coefficient of AIGS
parameter real AIGDL = 0.0;                     // Length dependence coefficient of AIGD
parameter real AIGDW = 0.0;                     // Width dependence coefficient of AIGD
parameter real PIGCDL = 0.0;                    // Length dependence coefficient of PIGCD

parameter real LAIGBINV = 0.0;
parameter real WAIGBINV = 0.0;
parameter real PAIGBINV = 0.0;

parameter real LBIGBINV = 0.0;
parameter real WBIGBINV = 0.0;
parameter real PBIGBINV = 0.0;

parameter real LCIGBINV = 0.0;
parameter real WCIGBINV = 0.0;
parameter real PCIGBINV = 0.0;

parameter real LEIGBINV = 0.0;
parameter real WEIGBINV = 0.0;
parameter real PEIGBINV = 0.0;

parameter real LNIGBINV = 0.0;
parameter real WNIGBINV = 0.0;
parameter real PNIGBINV = 0.0;

parameter real LAIGBACC = 0.0;
parameter real WAIGBACC = 0.0;
parameter real PAIGBACC = 0.0;

parameter real LBIGBACC = 0.0;
parameter real WBIGBACC = 0.0;
parameter real PBIGBACC = 0.0;

parameter real LCIGBACC = 0.0;
parameter real WCIGBACC = 0.0;
parameter real PCIGBACC = 0.0;

parameter real LNIGBACC = 0.0;
parameter real WNIGBACC = 0.0;
parameter real PNIGBACC = 0.0;

parameter real LAIGC = 0.0;
parameter real WAIGC = 0.0;
parameter real PAIGC = 0.0;

parameter real LBIGC = 0.0;
parameter real WBIGC = 0.0;
parameter real PBIGC = 0.0;

parameter real LCIGC = 0.0;
parameter real WCIGC = 0.0;
parameter real PCIGC = 0.0;

parameter real LAIGS = 0.0;
parameter real WAIGS = 0.0;
parameter real PAIGS = 0.0;

parameter real LBIGS = 0.0;
parameter real WBIGS = 0.0;
parameter real PBIGS = 0.0;

parameter real LCIGS = 0.0;
parameter real WCIGS = 0.0;
parameter real PCIGS = 0.0;

parameter real LAIGD = 0.0;
parameter real WAIGD = 0.0;
parameter real PAIGD = 0.0;

parameter real LBIGD = 0.0;
parameter real WBIGD = 0.0;
parameter real PBIGD = 0.0;

parameter real LCIGD = 0.0;
parameter real WCIGD = 0.0;
parameter real PCIGD = 0.0;

parameter real LPOXEDGE = 0.0;
parameter real WPOXEDGE = 0.0;
parameter real PPOXEDGE = 0.0;

parameter real LDLCIG = 0.0;
parameter real WDLCIG = 0.0;
parameter real PDLCIG = 0.0;

parameter real LDLCIGD = 0.0;
parameter real WDLCIGD = 0.0;
parameter real PDLCIGD = 0.0;

parameter real LNTOX = 0.0;
parameter real WNTOX = 0.0;
parameter real PNTOX = 0.0;

//GIDL/GISL Current
parameter real AGIDL    = 0.0;                  // pre-exponential coeff. for GIDL in mho
parameter real AGIDLL   = 0.0;                  // Length dependence coefficient of AGIDL
parameter real AGIDLW   = 0.0;                  // Width dependence coefficient of AGIDL
parameter real LAGIDL   = 0.0;
parameter real WAGIDL   = 0.0;
parameter real PAGIDL   = 0.0;
parameter real BGIDL    = 2.3e9;                // exponential coeff. for GIDL in V/m
parameter real LBGIDL   = 0.0;
parameter real WBGIDL   = 0.0;
parameter real PBGIDL   = 0.0;
parameter real CGIDL    = 0.5 from [0:inf);         // exponential coeff. for GIDL in V/m
parameter real LCGIDL   = 0.0;
parameter real WCGIDL   = 0.0;
parameter real PCGIDL   = 0.0;
parameter real EGIDL    = 0.8;                  // band bending parameter for GIDL in V
parameter real LEGIDL   = 0.0;
parameter real WEGIDL   = 0.0;
parameter real PEGIDL   = 0.0;
parameter real AGISL    = AGIDL;                // pre-exponential coeff. for GISL in mho
parameter real AGISLL   = AGIDLL;               // Length dependence coefficient of AGISL
parameter real AGISLW   = AGIDLW;               // Width dependence coefficient of AGISL
parameter real LAGISL   = LAGIDL;
parameter real WAGISL   = WAGIDL;
parameter real PAGISL   = PAGIDL;
parameter real BGISL    = BGIDL;                // exponential coeff. for GISL in V/m
parameter real LBGISL   = LBGIDL;
parameter real WBGISL   = WBGIDL;
parameter real PBGISL   = PBGIDL;
parameter real CGISL    = CGIDL from [0:inf);           // exponential coeff. for GISL in V/m
parameter real LCGISL   = LCGIDL;
parameter real WCGISL   = WCGIDL;
parameter real PCGISL   = PCGIDL;
parameter real EGISL    = EGIDL;                // band bending parameter for GISL in V
parameter real LEGISL   = LEGIDL;
parameter real WEGISL   = WEGIDL;
parameter real PEGISL   = PEGIDL;

// Overlap Cap and Fringing Cap
parameter real CF       = 0.0;                  // Outer Fringe Cap (F)
parameter real LCF      = 0.0;
parameter real WCF      = 0.0;
parameter real PCF      = 0.0;
parameter real CFRCOEFF = 1.0 from [1.0:inf);   // Coefficient for Outer Fringe Cap (F)
parameter real CGSO     = 0.0;                  // Gate - Source overlap capacitance (F)
parameter real CGDO     = 0.0;                  // Gate - Drain overlap capacitance (F)
parameter real CGBO     = 0.0;                  // Gate - Body overlap capacitance (F)
parameter real CGSL     = 0.0;
parameter real LCGSL    = 0.0;
parameter real WCGSL    = 0.0;
parameter real PCGSL    = 0.0;
parameter real CGDL     = 0.0;
parameter real LCGDL    = 0.0;
parameter real WCGDL    = 0.0;
parameter real PCGDL    = 0.0;
parameter real CKAPPAS  = 0.6 from (0:inf);
parameter real LCKAPPAS = 0.0;
parameter real WCKAPPAS = 0.0;
parameter real PCKAPPAS = 0.0;
parameter real CKAPPAD  = 0.6 from (0:inf);
parameter real LCKAPPAD = 0.0;
parameter real WCKAPPAD = 0.0;
parameter real PCKAPPAD = 0.0;

// Layout-Dependent Parasitics Model Parameters ....Resistance only
parameter real DMCG     = 0.0 ;                 // Distance of Mid-Contact to Gate edge [m]
parameter real DMCI     = DMCG;                 // Distance of Mid-Contact to Isolation [m]
parameter real DMDG     = 0.0;                  // Distance of Mid-Diffusion to Gate edge [m]
parameter real DMCGT    = 0.0;                  // Dist of Mid-Contact to Gate edge in Test [m]

`ifdef __RGATEMOD__
    parameter real XGW      = 0.0;                  // Dist from gate contact center to dev edge [m]
    parameter real XGL      = 0.0 from (-inf:L+XL); // Variation in Ldrawn [m]
    parameter integer NGCON = 1 from [1:2];         // Number of gate contacts
    parameter real RSHG     = 0.1 from [0:inf);     // Gate sheet resistance [Ohm]
`endif

// Junction current and capacitance
// Junction Capacitance
parameter real CJS      = 5.0e-4;               // Unit area source-side junction capacitance at zero bias
parameter real CJD      = CJS;                  // Unit area drain-side junction capacitance at zero bias
parameter real CJSWS    = 5.0e-10;              // Unit length source-side sidewall junction capacitance at zero bias
parameter real CJSWD    = CJSWS;                // Unit length drain-side sidewall junction capacitance at zero bias
parameter real CJSWGS   = 0.0;                  // Unit length source-side gate sidewall junction capacitance at zero bias
parameter real CJSWGD   = CJSWGS;               // Unit length drain-side gate sidewall junction capacitance at zero bias
parameter real PBS      = 1.0;                  // Source-side bulk junction built-in potential
parameter real PBD      = PBS;                  // Drain-side bulk junction built-in potential
parameter real PBSWS    = 1.0;                  // Built-in potential for Source-side sidewall junction capacitance
parameter real PBSWD    = PBSWS;                // Built-in potential for Drain-side sidewall junction capacitance
parameter real PBSWGS   = PBSWS;                // Built-in potential for Source-side gate sidewall junction capacitance
parameter real PBSWGD   = PBSWGS;               // Built-in potential for Drain-side gate sidewall junction capacitance
parameter real MJS      = 0.5     from (0:1);   // Source bottom junction capacitance grading coefficient
parameter real MJD      = MJS     from (0:1);   // Drain bottom junction capacitance grading coefficient
parameter real MJSWS    = 0.33    from (0:1);   // Source sidewall junction capacitance grading coefficient
parameter real MJSWD    = MJSWS   from (0:1);   // Drain sidewall junction capacitance grading coefficient
parameter real MJSWGS   = MJSWS   from (0:1);   // Source-side gate sidewall junction capacitance grading coefficient
parameter real MJSWGD   = MJSWGS  from (0:1);   // Drain-side gate sidewall junction capacitance grading coefficient

// Junction Current
parameter real JSS      = 1.0e-4;               // Bottom source junction reverse saturation current density
parameter real JSD      = JSS;                  // Bottom drain junction reverse saturation current density
parameter real JSWS     = 0.0;                  // Unit length reverse saturation current for sidewall source junction
parameter real JSWD     = JSWS;                 // Unit length reverse saturation current for sidewall drain junction
parameter real JSWGS    = 0.0;                  // Unit length reverse saturation current for gate-edge sidewall source junction
parameter real JSWGD    = JSWGS;                // Unit length reverse saturation current for gate-edge sidewall drain junction
parameter real NJS      = 1.0 from (0:inf);     // Source junction emission coefficient
parameter real NJD      = NJS from (0:inf);     // Drain junction emission coefficient
parameter real IJTHSFWD = 0.1;                  // Forward source diode breakdown limiting current
parameter real IJTHDFWD = IJTHSFWD;             // Forward drain diode breakdown limiting current
parameter real IJTHSREV = 0.1;                  // Reverse source diode breakdown limiting current
parameter real IJTHDREV = IJTHSREV;             // Reverse drain diode breakdown limiting current
parameter real BVS      = 10.0;                 // Source diode breakdown voltage
parameter real BVD      = BVS;                  // Drain diode breakdown voltage
parameter real XJBVS    = 1.0     from (0:inf); // Fitting parameter for source diode breakdown current
parameter real XJBVD    = XJBVS   from (0:inf); // Fitting parameter for drain diode breakdown current

// Tunneling Component of Junction Current
parameter real JTSS     = 0.0;                  // Bottom source junction trap-assisted saturation current density
parameter real JTSD     = JTSS;                 // Bottom drain junction trap-assisted saturation current density
parameter real JTSSWS   = 0.0;                  // Unit length trap-assisted saturation current for sidewall source junction
parameter real JTSSWD   = JTSSWS;               // Unit length trap-assisted saturation current for sidewall drain junction
parameter real JTSSWGS  = 0.0;                  // Unit length trap-assisted saturation current for gate-edge sidewall source junction
parameter real JTSSWGD  = JTSSWGS;              // Unit length trap-assisted saturation current for gate-edge sidewall drain junction
parameter real JTWEFF   = 0.0 from [0:inf);     // Trap assisted tunneling current width dependence
parameter real NJTS     = 20.0;                 // Non-ideality factor for JTSS
parameter real NJTSD    = NJTS;                 // Non-ideality factor for JTSD
parameter real NJTSSW   = 20.0;                 // Non-ideality factor for JTSSWS
parameter real NJTSSWD  = NJTSSW;               // Non-ideality factor for JTSSWD
parameter real NJTSSWG  = 20.0;                 // Non-ideality factor for JTSSWGS
parameter real NJTSSWGD = NJTSSWG;              // Non-ideality factor for JTSSWGD
parameter real VTSS     = 10.0;                 // Bottom source junction trap-assisted current voltage dependent parameter
parameter real VTSD     = VTSS;                 // Bottom drain junction trap-assisted current voltage dependent parameter
parameter real VTSSWS   = 10.0;                 // Unit length trap-assisted current voltage dependent parameter
// for sidewall source junction
parameter real VTSSWD   = VTSSWS;               // Unit length trap-assisted current voltage dependent parameter
// for sidewall drain junction
parameter real VTSSWGS  = 10.0;                 // Unit length trap-assisted current voltage dependent parameter for
// gate-edge sidewall source junction
parameter real VTSSWGD  = VTSSWGS;              // Unit length trap-assisted current voltage dependent parameter for
// gate-edge sidewall drain junction

// High-Speed/RF Model Parameters
`ifdef __RGATEMOD__
    parameter real XRCRG1   = 12.0;             // 1st fitting parm the bias-dependent Rg //make it binnable
    parameter real XRCRG2   = 1.0;              // 2nd fitting parm the bias-dependent Rg  //make it binnable
`endif
`ifdef __RBODYMOD__
    parameter real RBPB     = 50.0 from [0:inf);    // Resistance between bNodePrime and bNode [Ohm]
    parameter real RBDB     = 50.0 from [0:inf);    // Resistance between bNode and dbNode [Ohm]
    parameter real RBSB     = 50.0 from [0:inf);    // Resistance between bNode and sbNode [Ohm]
    parameter real RBPS     = 50.0 from [0:inf);    // Resistance between bNodePrime and sbNode [Ohm]
    parameter real RBPD     = 50.0 from [0:inf);    // Resistance between bNodePrime and bNode [Ohm]
    parameter real GBMIN    = 1.0e-12 from [0:inf); // Minimum body conductance
    parameter real RBPS0    = 50.0 from (0:inf);    // Scaling prefactor for RBPS 50 Ohms
    parameter real RBPSL    = 0.0 from [0:inf);     //Length Scaling parameter for RBPS
    parameter real RBPSW    = 0.0 from [0:inf);     //Width Scaling parameter for RBPS
    parameter real RBPSNF   = 0.0 from [0:inf);     //Number of fingers Scaling parameter for RBPS
    parameter real RBPD0    = 50.0 from (0:inf);    //Scaling prefactor for RBPD
    parameter real RBPDL    = 0.0 from [0:inf);     // Length Scaling parameter for RBPD
    parameter real RBPDW    = 0.0 from [0:inf);     // Width Scaling parameter for RBPD
    parameter real RBPDNF   = 0.0 from [0:inf);     // Number of fingers Scaling parameter for RBPD
    parameter real RBPBX0   = 100.0 from (0:inf);   //Scaling prefactor for RBPBX
    parameter real RBPBXL   = 0.0 from [0:inf);     // Length Scaling parameter for RBPBX
    parameter real RBPBXW   = 0.0 from [0:inf);     // Width Scaling parameter for RBPBX
    parameter real RBPBXNF  = 0.0 from [0:inf);     // Number of fingers Scaling parameter for RBPBX
    parameter real RBPBY0   = 100.0 from (0:inf);   // Scaling prefactor for RBPBY
    parameter real RBPBYL   = 0.0 from [0:inf);     // Length Scaling parameter for RBPBY
    parameter real RBPBYW   = 0.0 from [0:inf);     // Width Scaling parameter for RBPBY
    parameter real RBPBYNF  = 0.0 from [0:inf);     // Number of fingers Scaling parameter for RBPBY
    parameter real RBSBX0   = 100.0 from (0:inf);   // Scaling prefactor for RBSBX
    parameter real RBSBY0   = 100.0 from (0:inf);   // Scaling prefactor for RBSBY
    parameter real RBDBX0   = 100.0 from (0:inf);   // Scaling prefactor for RBDBX
    parameter real RBDBY0   = 100.0 from (0:inf);   // Scaling prefactor for RBDBY
    parameter real RBSDBXL  = 0.0 from [0:inf);     // Length Scaling parameter for RBSBX and RBDBX
    parameter real RBSDBXW  = 0.0 from [0:inf);     // Width Scaling parameter for RBSBX and RBDBX
    parameter real RBSDBXNF = 0.0 from [0:inf);     // Number of fingers Scaling parameter for RBSBX and RBDBX
    parameter real RBSDBYL  = 0.0 from [0:inf);     // Length Scaling parameter for RBSBY and RBDBY
    parameter real RBSDBYW  = 0.0 from [0:inf);     // Width Scaling parameter for RBSBY and RBDBY
    parameter real RBSDBYNF = 0.0 from [0:inf);     // Number of fingers Scaling parameter for RBSBY and RBDBY
`endif

// Flicker Noise
parameter real EF       = 1.0 from (0:2];       // Flicker Noise frequency exponent
parameter real EM       = 4.1e7;
parameter real NOIA     = 6.250e+40;
parameter real NOIB     = 3.125e+25;
parameter real NOIC     = 8.750e+8;
parameter real LINTNOI  = 0.0;

// Thermal Noise
parameter real NTNOI = 1.0  from [0:inf);
`ifdef __TNOISW__
    parameter real RNOIA = 0.577;               // TNOIMOD = 1
    parameter real RNOIB = 0.5164;              // TNOIMOD = 1
    parameter real RNOIC = 0.395;               // TNOIMOD = 1
    parameter real TNOIA = 0.0 from [0:inf);        // TNOIMOD = 1
    parameter real TNOIB = 0.0 from [0:inf);        // TNOIMOD = 1
    parameter real TNOIC = 0.0 from [0:inf);        // Correlation coefficient
`endif

// Temperature Dependence Parameters
parameter real TNOM     = 27.0;                 // Temperature at which the model was extracted (degrees)
parameter real DTEMP    = 0.0;                  // Offset of Device Temperature

parameter real TBGASUB  = 4.73e-4;              // Bandgap Temperature Coefficient (eV / degrees)
parameter real TBGBSUB  = 636.0;                // Bandgap Temperature Coefficient (degrees)

parameter real TNFACTOR = 0.0;                  // Temperature exponent for NFACTOR

parameter real UTE  = -1.5;                 // Mobility temperature exponent
parameter real LUTE     = 0.0;
parameter real WUTE     = 0.0;
parameter real PUTE     = 0.0;
parameter real UTEL     = 0.0;                  // Length Scaling parameter for UTE

parameter real UA1  = 1.0e-3;               // Temperature coefficient for UA
parameter real LUA1     = 0.0;
parameter real WUA1     = 0.0;
parameter real PUA1     = 0.0;
parameter real UA1L     = 0.0;                  // Length Scaling parameter for UA1

parameter real UC1  = 0.056e-9;             // Temperature coefficient for UC
parameter real LUC1     = 0.0;
parameter real WUC1     = 0.0;
parameter real PUC1     = 0.0;
parameter real UD1  = 0.0;                  // Temperature coefficient for UD
parameter real LUD1     = 0.0;
parameter real WUD1     = 0.0;
parameter real PUD1     = 0.0;
parameter real UD1L     = 0.0;                  // Length Scaling parameter for UD1

parameter real UCSTE    = -4.775e-3;                // Temperature coefficient for UCS
parameter real LUCSTE   = 0.0;
parameter real WUCSTE   = 0.0;
parameter real PUCSTE   = 0.0;

parameter real TETA0    = 0.0;                  // Temperature coefficient for ETA0

parameter real PRT  = 0.0;                  // Temperature coefficient for resistance
parameter real LPRT     = 0.0;
parameter real WPRT     = 0.0;
parameter real PPRT     = 0.0;

parameter real AT   = -1.56e-3;             // Temperature coefficient for saturation velocity
parameter real LAT  = 0.0;
parameter real WAT  = 0.0;
parameter real PAT  = 0.0;
parameter real ATL  = 0.0;                  // Length Scaling parameter for AT

parameter real TDELTA   = 0.0;                  // Temperature coefficient for DELTA

parameter real PTWGT    = 0.0;                  // Temperature coefficient for PTWG
parameter real LPTWGT   = 0.0;
parameter real WPTWGT   = 0.0;
parameter real PPTWGT   = 0.0;
parameter real PTWGTL   = 0.0;                  // Length Scaling parameter for PTWGT

parameter real KT1  = -0.11;                // Temperature coefficient for Vth
parameter real KT1EXP   = 1.0 from (0:inf);         // Temperature coefficient for Vth
parameter real KT1L = 0.0;                  // Temperature coefficient for Vth
parameter real KT2  = 0.022;                // Temperature coefficient for Vth

parameter real IIT  = 0.0;                  // Temperature coefficient for BETA0
parameter real LIIT = 0.0;
parameter real WIIT = 0.0;
parameter real PIIT = 0.0;

parameter real IGT  = 2.5;                  // Gate Current Temperature Dependence
parameter real LIGT = 0.0;
parameter real WIGT = 0.0;
parameter real PIGT = 0.0;

parameter real TGIDL    = 0.0;                  // Temperature coefficient for GIDL/GISL
parameter real LTGIDL   = 0.0;
parameter real WTGIDL   = 0.0;
parameter real PTGIDL   = 0.0;

parameter real TCJ  = 0.0;                  // Temperature coefficient for CJS/CJD
parameter real TCJSW    = 0.0;                  // Temperature coefficient for CJSWS/CJSWD
parameter real TCJSWG   = 0.0;                  // Temperature coefficient for CJSWGS/CJSWGD
parameter real TPB  = 0.0;                  // Temperature coefficient for PBS/PBD
parameter real TPBSW    = 0.0;                  // Temperature coefficient for PBSWS/PBSWD
parameter real TPBSWG   = 0.0;                  // Temperature coefficient for PBSWGS/PBSWGD
parameter real XTIS     = 3.0;                  // Source junction current temperature exponent
parameter real XTID     = XTIS;                 // Drain junction current temperature exponent
parameter real XTSS     = 0.02;                 // Power dependence of JTSS on temperature
parameter real XTSD     = XTSS;                 // Power dependence of JTSD on temperature
parameter real XTSSWS   = 0.02;                 // Power dependence of JTSSWS on temperature
parameter real XTSSWD   = XTSSWS;               // Power dependence of JTSSWD on temperature
parameter real XTSSWGS  = 0.02;                 // Power dependence of JTSSWGS on temperature
parameter real XTSSWGD  = XTSSWGS;              // Power dependence of JTSSWGD on temperature
parameter real TNJTS    = 0.0;                  // Temperature coefficient for NJTS
parameter real TNJTSD   = TNJTS;                // Temperature coefficient for NJTSD
parameter real TNJTSSW  = 0.0;                  // Temperature coefficient for NJTSSW
parameter real TNJTSSWD = TNJTSSW;              // Temperature coefficient for NJTSSWD
parameter real TNJTSSWG = 0.0;                  // Temperature coefficient for NJTSSWG
parameter real TNJTSSWGD = TNJTSSWG;                // Temperature coefficient for NJTSSWGD

//Stress related Parameter
parameter real SA   = 0.0;                  // Distance between OD edge from Poly from one side
parameter real SB   = 0.0;                  // Distance between OD edge from Poly from other side
parameter real SD   = 0.0;                  // Distance between neighboring fingers
parameter real SAREF    = 1.0e-6 from (0:inf);          // Reference distance between OD edge from Poly from one side
parameter real SBREF    = 1.0e-6 from (0:inf);          // Reference distance between OD edge from Poly from other side
parameter real WLOD     = 0.0;                  // Width Parameter for Stress Effect
parameter real KU0  = 0.0;                  // Mobility degradation/enhancement Parameter for Stress Effect
parameter real KVSAT    = 0.0;                  // Saturation Velocity degradation/enhancement Parameter for Stress Effect
parameter real TKU0     = 0.0;                  // Temperature Coefficient for KU0
parameter real LKU0     = 0.0;                  // Length Dependence of KU0
parameter real WKU0     = 0.0;                  // Width Dependence of KU0
parameter real PKU0     = 0.0;                  // Cross Term Dependence of KU0
parameter real LLODKU0  = 0.0;                  // Length Parameter for u0 stress effect
parameter real WLODKU0  = 0.0;                  // Width Parameter for u0 stress effect
parameter real KVTH0    = 0.0;                  // Threshold Shift parameter for stress effect
parameter real LKVTH0   = 0.0;                  // Length dependence of KVTH0
parameter real WKVTH0   = 0.0;                  // Width dependence of KVTH0
parameter real PKVTH0   = 0.0;                  // Cross-term dependence of KVTH0
parameter real LLODVTH  = 0.0;                  // Length Parameter for Vth stress effect
parameter real WLODVTH  = 0.0;                  // Width Parameter for Vth stress effect
parameter real STK2     = 0.0;                  // K2 shift factor related to Vth change
parameter real LODK2    = 0.0;                  // K2 shift modification factor for stress effect
parameter real STETA0   = 0.0;                  // eta0 shift related to Vth0 change
parameter real LODETA0  = 0.0;                  // eta0 modification foator for stress effect
//Well Proximity Parameters
parameter real SCA  = 0.0;                  //Integration of first distribution function for scattered well dopant
parameter real SCB  = 0.0;                  //Integration of second distribution function for scattered well dopant
parameter real SCC  = 0.0;                  //Integration of second distribution function for scattered well dopant
parameter real SC   = 0.0;                  //Distance to a single well edge
parameter real WEB  = 0.0;                  //Coefficient for SCB
parameter real WEC  = 0.0;                  //Coefficient for SCC
parameter real KVTH0WE  = 0.0;                  //Vth shift for well proximity effect
parameter real K2WE     = 0.0;                  //K2 shift for well proximity effect
parameter real KU0WE    = 0.0;                  //Mobility degradation factor for well proximity effect
parameter real SCREF    = 1.0e-6;               //Reference distance to calculate SCA,SCB and SCC

// GMIN - added for convergence
parameter real GMIN     = $simparam("gmin", 1.0e-15);

// ***********************************
//   Variables
// ***********************************

// Common Variables
real T0, T1, T2, T3, T4, T5, T6, T7, T8, T9, T10, T11, T12;
real Tb;
real epssi, epsox, ni, Weff, Leff, Wact, Lact, Weffcj, Eg, Eg0;
real dLIV, dWIV, dLCV, dWCV, dWJ, Cox, epsratio;
real Vdb_noswap, Vsb_noswap, Vgs_noswap, Vgd_noswap;
real sigvds, vfb, vgfb, vgfbCV, Vbsx, Vfbsdr;
real Vg, vg, Vd, Vs, vs, Vds, Vdsx, Vgs_eff, Vgd_eff;
real Vth_shift;
real qia, qba, qiaCV, qbaCV, qbs, qbd, qb, dps, phib, phib_n;
real nq, psip, psiavg, psipclamp, sqrtpsisa, sqrtpsisainv, sqrtpsip;
real Cdep, Lnew;

// Short Channel Effects
real n, Fp, nVt, inv_nVt, Vt, inv_Vt ;
real PhistVbs, sqrtPhistVbs, Xdep, cdsc;
real T1DEP;
real dVth_ldop, DVTP0_i, DVTP1_i, DVTP2_i, DVTP3_i, DVTP4_i, DVTP5_i;
real dVth_VNUD, dVth_dibl, dvth_temp;
real gam, inv_gam, Phist, sqrtPhist, litl;

// Drain Saturation Voltage
real qis, qdsat, Eeffs, Dmobs, Esat, EsatL, Vdsat, LambdaC_by2, LambdaC;
real Vdseff, Vdssat, VdssatCV, vdeff, vdsat, qdeff, vdsatcv, VdsatCV;
real ln_T1_T2;

// Mobility Degradation
real EeffFactor, Eeffm, ueff, eta_mu, Dmob, Dtot;

// Velocity Saturation
real zsat, Dvsat, Dptwg, PSAT_i;

// Output Conductance
real diffVds, VaDITS, VaSCBE, Vasat;
real DIBLfactor, PVAGfactor, VaDIBL, Vgst2Vtm, Moc, MdL, Mscbe;

//Impact Ionization and GIDL
real Iii, igidl, igisl;

// IV Variables
integer devsign;
real ids;

// CV Variables
real Qb, Qs, Qd1, Qd2, Qd, Qi, QBi, QSi, QDi, QGi, WLCOXVtinv;
real qs, qbeff, dqgeff;
real DPD, vgfbPD, gammaPD, gamg2;
real MdL_2, inv_MdL, inv_MdL_2, MdL_less_1;
real sis, sid, vgpqm, Temps, Tempd, DQSD, DQSD2, invgamg2;
real Vgsov, Vgdov, Qovb, Qovg, Qovs, Qovd, Cgsof, Cgdof;
real XDCinv, Coxeffinv, BSIM6TOXP;
real Vgd_ov_noswap, Vgs_ov_noswap;

// S/D Series Resistance
real WeffWRFactor, Rtot, DMCGeff, DMDGeff, DMCIeff;
real RSourceGeo, RDrainGeo, Rsource, Rdrain, Rdss, Rdsi, Dr;

//Gate Resistances
`ifdef __RGATEMOD__
    real Grgeltd, Gcrg, idsovvds;
`endif

//Body Resistance
`ifdef __RBODYMOD__
    real Lnl, Lnw, Lnnf, Bodymode, Rbpbx, Rbpby, Rbsbx, Rbsby, Rbdbx, Rbdby;
    real Rbdb, Rbsb, Rbpb, Rbps, Rbpd;
    real Grbsb, Grbdb, Grbpb, Grbps, Grbpd;
`endif

// Gate Current
real Voxm, Voxminv, Voxmacc, Vdseffx;
real Vaux_Igbinv, Vaux_Igbacc, igbinv, igbacc, igb;
real igcs, igcd, igc0, T1_exp;
real igs, igd, igs_mult, igd_mult;
real Aechvb, Bechvb, AechvbEdge, BechvbEdge, ToxRatio, ToxRatioEdge;

// Junction Current and Capacitance
real PSeff, PDeff;
real Ibs, Ibd, Vbs_jct, Vbd_jct;
real Czbs, Czbssw, Czbsswg, Czbd, Czbdsw, Czbdswg;
real arg, sarg, Qbs, Qbd;
real Isbs, Isbd, Nvtms, Nvtmd;
real SslpRev, IVjsmRev, VjsmRev, SslpFwd, IVjsmFwd, VjsmFwd, XExpBVS;
real DslpRev, IVjdmRev, VjdmRev, DslpFwd, IVjdmFwd, VjdmFwd, XExpBVD;

// Flicker Noise
real LINTNOI_i;
real Esatnoi, Leffnoi, Leffnoisq, DelClm;
real N0, Nl, Nstar, Ssi, Swi, FNPowerAt1Hz;

// Thermal Noise
real gspr, gdpr;
real Gtnoi, sidn, Nt;
`ifdef __TNOISW__
    real mig, migid, mid, Lvsat, Vtn;
    real cm_igid, sqid, sqig, ctnoi, betanoisq, thetanoisq;
`endif

// Temperature Effects
real DevTemp, Tnom, Vtm, Vtm0;
real TRatio, delTemp;
real U0_t, UA_t, UC_t, UD_t, UCS_t, rdstemp, VSAT_t, VSATCV_t ;
real DELTA_t, PTWG_t, BETA0_t, BGIDL_t, BGISL_t;
real igtemp;
real ETA0_t, NFACTOR_t;

//Diode temperature effects
real CJS_t, CJSWS_t, CJSWGD_t, CJD_t, CJSWD_t, CJSWGS_t;
real PBS_t, PBSWS_t, PBSWGS_t, PBD_t, PBSWD_t, PBSWGD_t;
real JSS_t, JSWS_t, JSWGS_t, JSD_t, JSWD_t, JSWGD_t;
real JTSS_t, JTSD_t, JTSSWS_t, JTSSWD_t, JTSSWGS_t, JTSSWGD_t;
real NJTS_t, NJTSD_t, NJTSSW_t, NJTSSWD_t, NJTSSWG_t, NJTSSWGD_t;

// Binning
real W_by_NF;
real L_LLN, W_LWN, LW_LLN_LWN;
real L_WLN, W_WWN, LW_WLN_WWN;
real Inv_L, Inv_W, Inv_WL, Inv_Lact, Inv_Wact, Inv_Llong, Inv_Wwide;
real NGATE_i, NSD_i, NDEP_i, VFB_i;
real CIT_i, CDSCD_i, CDSCB_i, NFACTOR_i;
real PHIN_i, ETA0_i, ETAB_i, K2_i;
real DELTA_i;
real U0_i, VSAT_i, VSATCV_i, UA_i, EU_i, UD_i, UCS_i, UC_i;
real PDIBLC_i, PDIBLCB_i, PSCBE1_i, PSCBE2_i, PDITS_i, PDITSD_i, FPROUT_i;
real PRWG_i, WR_i, RDWMIN_i, RSWMIN_i, RDW_i, RSW_i, RDSW_i, RDSWMIN_i;
real PTWG_i, PVAG_i, XJ_i;
real PCLM_i, PCLMCV_i, PRWB_i;
real CF_i, CGSL_i, CGDL_i, CKAPPAS_i, CKAPPAD_i;
real VFBCV_i, NDEPCV_i;
real ALPHA0_i, BETA0_i;
real AGIDL_i, BGIDL_i, CGIDL_i, EGIDL_i;
real AGISL_i, BGISL_i, CGISL_i, EGISL_i;
real UTE_i, UA1_i, UC1_i, UD1_i, UCSTE_i, PRT_i, AT_i, PTWGT_i, IIT_i, TGIDL_i;

real AIGBINV_i, BIGBINV_i, CIGBINV_i, EIGBINV_i, NIGBINV_i;
real AIGBACC_i, BIGBACC_i, CIGBACC_i, NIGBACC_i;
real AIGC_i, BIGC_i, CIGC_i;
real AIGS_i, BIGS_i, CIGS_i, AIGD_i, BIGD_i, CIGD_i, POXEDGE_i, PIGCD_i;
real DLCIG_i, DLCIGD_i, NTOX_i;
real IGT_i;

//stress effect
real W_tmp_stress, tmp1_stress, kstress_u0, tmp1_stress_vth, kstress_vth0, ku0_temp;
real Inv_sa, Inv_sb, Inv_saref, Inv_sbref, Inv_odref, rho_ref, Inv_od,rho;
real mu0_mult, vsat_mult, vth0_stress, k2_stress, eta_stress;
integer i;

//Well Proximity effect
real vth0_well, k2_well, mu_well;

// The following are used by the macro definitions (GEOMOD and RGEOMOD )
real nuIntD, nuEndD, nuIntS, nuEndS;
real Rint, Rend;

// ---- OPERATING POINT VARIABLES ----

(* desc="QBI"   *) real QBI;
(* desc="QSI"   *) real QSI;
(* desc="QDI"   *) real QDI;
(* desc="QGI"   *) real QGI;

(* desc="CGGI"  *) real CGGI;
(* desc="CGBI"  *) real CGBI;
(* desc="CGSI"  *) real CGSI;
(* desc="CGDI"  *) real CGDI;

(* desc="CSGI"  *) real CSGI;
(* desc="CSBI"  *) real CSBI;
(* desc="CSSI"  *) real CSSI;
(* desc="CSDI"  *) real CSDI;

(* desc="CDGI"  *) real CDGI;
(* desc="CDBI"  *) real CDBI;
(* desc="CDSI"  *) real CDSI;
(* desc="CDDI"  *) real CDDI;

(* desc="CBGI"  *) real CBGI;
(* desc="CBBI"  *) real CBBI;
(* desc="CBSI"  *) real CBSI;
(* desc="CBDI"  *) real CBDI;

(* desc="QB"    *) real QB;
(* desc="QS"    *) real QS;
(* desc="QD"    *) real QD;
(* desc="QG"    *) real QG;

(* desc="CGG"   *) real CGG;
(* desc="CGB"   *) real CGB;
(* desc="CGS"   *) real CGS;
(* desc="CGD"   *) real CGD;

(* desc="CSG"   *) real CSG;
(* desc="CSB"   *) real CSB;
(* desc="CSS"   *) real CSS;
(* desc="CSD"   *) real CSD;

(* desc="CDG"   *) real CDG;
(* desc="CDB"   *) real CDB;
(* desc="CDS"   *) real CDS;
(* desc="CDD"   *) real CDD;

(* desc="CBG"   *) real CBG;
(* desc="CBB"   *) real CBB;
(* desc="CBS"   *) real CBS;
(* desc="CBD"   *) real CBD;

(* desc="III"   *) real III;
(* desc="IGIDL" *) real IGIDL;
(* desc="IGISL" *) real IGISL;

(* desc="IGS"   *) real IGS;
(* desc="IGD"   *) real IGD;
(* desc="IGCS"  *) real IGCS;
(* desc="IGCD"  *) real IGCD;
(* desc="IGB"   *) real IGB;

(* desc="CGSEXT"*) real CGSEXT;
(* desc="CGDEXT"*) real CGDEXT;
(* desc="CGBOV" *) real CGBOV;

(* desc="CJST"  *) real CJST;
(* desc="CJDT"  *) real CJDT;

(* desc="WEFF"  *) real WEFF;
(* desc="LEFF"  *) real LEFF;
(* desc="WEFFCV"*) real WEFFCV;
(* desc="LEFFCV"*) real LEFFCV;

(* desc="IDS"   *) real IDS;
(* desc="IDEFF" *) real IDEFF;
(* desc="ISEFF" *) real ISEFF;
(* desc="IGEFF" *) real IGEFF;
(* desc="IJSB"  *) real IJSB;
(* desc="IJDB"  *) real IJDB;

(* desc="VDS"   *) real VDS;
(* desc="VGS"   *) real VGS;
(* desc="VSB"   *) real VSB;
(* desc="VDSSAT"*) real VDSSAT;

(* desc="GM"    *) real GM;
(* desc="GMBS"  *) real GMBS;
(* desc="GDS"   *) real GDS;

analog begin
    // Bias independent calculations
    if ( TYPE == `ntype ) devsign = 1;
    else devsign = -1;

    // Constants
    //ni        = NI0SUB;
    epssi   = EPSRSUB * `EPS0;
    epsox   = EPSROX * `EPS0;
    Cox     = EPSROX * `EPS0 / TOXE;
    epsratio = EPSRSUB / EPSROX;

    //Physical Oxide Thickness
    if (!$param_given(TOXP))
        BSIM6TOXP = (TOXE*EPSROX/3.9) - DTOX; // valid for any dielectric
    else
        BSIM6TOXP = TOXP;

    // Binning
    //Leff and Weff for IV
    W_by_NF     = W/NF;
    L_LLN       = pow(L, -LLN);
    W_LWN       = pow(W_by_NF, -LWN);
    LW_LLN_LWN  = L_LLN*W_LWN;
    dLIV        = LINT + LL * L_LLN + LW * W_LWN + LWL * LW_LLN_LWN;
    L_WLN       = pow(L, -WLN);
    W_WWN       = pow(W_by_NF, -WWN);
    LW_WLN_WWN  = L_WLN*W_WWN;
    dWIV        = WINT + WL * L_WLN + WW * W_WWN + WWL * LW_WLN_WWN;
    Leff        = L + XL - 2.0*dLIV;
    Weff        = W_by_NF + XW - 2.0*dWIV;
    //Leff and Weff for CV
    dLCV        = DLC + LLC * L_LLN + LWC * W_LWN + LWLC * LW_LLN_LWN;
    dWCV        = DWC + WLC * L_WLN + WWC * W_WWN + WWLC * LW_WLN_WWN;
    Lact        = L + XL - 2.0*dLCV;
    Wact        = W_by_NF + XW - 2.0*dWCV;
    //L for gate resistance and stress effect
    Lnew = L + XL;

    //Weffcj for Diode, GIDL etc.
    dWJ         = DWJ + WLC / pow(L,WLN) + WWC / pow(W,WWN) + WWLC / pow(L,WLN) / pow(W,WWN);
    Weffcj      = W_by_NF + XW - 2.0*dWJ;

    Inv_L       = 1.0e-6 / Leff;
    Inv_W       = 1.0e-6 / Weff;
    Inv_Lact    = 1.0e-6 / Lact;
    Inv_Wact    = 1.0e-6 / Wact;
    Inv_Llong   = 1.0e-6 / LLONG;
    Inv_Wwide   = 1.0e-6 / WWIDE;
    Inv_WL      = Inv_L * Inv_W;

    VFB_i       = VFB       + LVFB * Inv_L      + WVFB * Inv_W      + PVFB * Inv_WL;
    VFBCV_i     = VFBCV     + LVFBCV * Inv_L    + WVFBCV * Inv_W    + PVFBCV * Inv_WL;
    NSD_i       = NSD       + LNSD * Inv_L      + WNSD * Inv_W      + PNSD * Inv_WL;
    NDEP_i      = NDEP      + LNDEP * Inv_L     + WNDEP * Inv_W     + PNDEP * Inv_WL;
    NDEPCV_i    = NDEPCV    + LNDEPCV * Inv_L   + WNDEPCV * Inv_W   + PNDEPCV * Inv_WL;
    NGATE_i     = NGATE     + Inv_L * LNGATE    + Inv_W * WNGATE    + Inv_WL * PNGATE;
    CIT_i       = CIT       + LCIT * Inv_L      + WCIT * Inv_W      + PCIT * Inv_WL;
    NFACTOR_i   = NFACTOR   + LNFACTOR * Inv_L  + WNFACTOR * Inv_W  + PNFACTOR * Inv_WL;
    CDSCD_i     = CDSCD     + LCDSCD * Inv_L    + WCDSCD * Inv_W    + PCDSCD * Inv_WL;
    CDSCB_i     = CDSCB     + LCDSCB * Inv_L    + WCDSCB * Inv_W    + PCDSCB * Inv_WL;
    DVTP0_i     = DVTP0     + LDVTP0 * Inv_L    + WDVTP0 * Inv_W    + PDVTP0 * Inv_WL;
    DVTP1_i     = DVTP1     + LDVTP1 * Inv_L    + WDVTP1 * Inv_W    + PDVTP1 * Inv_WL;
    DVTP2_i     = DVTP2     + LDVTP2 * Inv_L    + WDVTP2 * Inv_W    + PDVTP2 * Inv_WL;
    DVTP3_i     = DVTP3     + LDVTP3 * Inv_L    + WDVTP3 * Inv_W    + PDVTP3 * Inv_WL;
    DVTP4_i     = DVTP4     + LDVTP4 * Inv_L    + WDVTP4 * Inv_W    + PDVTP4 * Inv_WL;
    DVTP5_i     = DVTP5     + LDVTP5 * Inv_L    + WDVTP5 * Inv_W    + PDVTP5 * Inv_WL;
    K2_i        = K2        + LK2 * Inv_L       + WK2 * Inv_W       + PK2 * Inv_WL;
    XJ_i        = XJ        + LXJ * Inv_L       + WXJ * Inv_W       + PXJ * Inv_WL;
    PHIN_i      = PHIN      + LPHIN * Inv_L     + WPHIN * Inv_W     + PPHIN * Inv_WL;
    ETA0_i      = ETA0      + LETA0 * Inv_L     + WETA0 * Inv_W     + PETA0 * Inv_WL;
    ETAB_i      = ETAB      + LETAB * Inv_L     + WETAB * Inv_W     + PETAB * Inv_WL;
    DELTA_i     = DELTA     + LDELTA * Inv_L    + WDELTA * Inv_W    + PDELTA * Inv_WL;
    U0_i        = U0        + LU0 * Inv_L       + WU0 * Inv_W       + PU0 * Inv_WL;
    UA_i        = UA        + LUA * Inv_L       + WUA * Inv_W       + PUA * Inv_WL;
    UD_i        = UD        + LUD * Inv_L       + WUD * Inv_W       + PUD * Inv_WL;
    EU_i        = EU        + Inv_L * LEU       + Inv_W * WEU       + Inv_WL * PEU;
    UCS_i       = UCS       + Inv_L * LUCS      + Inv_W * WUCS      + Inv_WL * PUCS;
    UC_i        = UC        + Inv_L * LUC       + Inv_W * WUC       + Inv_WL * PUC;
    PCLM_i      = PCLM      + LPCLM * Inv_L     + WPCLM * Inv_W     + PPCLM * Inv_WL;
    PCLMCV_i    = PCLMCV    + LPCLMCV * Inv_L   + WPCLMCV * Inv_W   + PPCLMCV * Inv_WL;

    RSW_i       = RSW       + LRSW * Inv_L      + WRSW * Inv_W      + PRSW * Inv_WL;
    RDW_i       = RDW       + LRDW * Inv_L      + WRDW * Inv_W      + PRDW * Inv_WL;
    PRWG_i      = PRWG      + LPRWG * Inv_L     + WPRWG * Inv_W     + PPRWG * Inv_WL;
    PRWB_i      = PRWB      + LPRWB * Inv_L     + WPRWB * Inv_W     + PPRWB * Inv_WL;
    WR_i        = WR        + LWR * Inv_L       + WWR * Inv_W       + PWR * Inv_WL;
    RSWMIN_i    = RSWMIN    + LRSWMIN * Inv_L   + WRSWMIN * Inv_W   + PRSWMIN * Inv_WL;
    RDWMIN_i    = RDWMIN    + LRDWMIN * Inv_L   + WRDWMIN * Inv_W   + PRDWMIN * Inv_WL;
    RDSW_i      = RDSW      + LRDSW * Inv_L     + WRDSW * Inv_W     + PRDSW * Inv_WL;
    RDSWMIN_i   = RDSWMIN   + LRDSWMIN * Inv_L  + WRDSWMIN * Inv_W  + PRDSWMIN * Inv_WL;

    PTWG_i      = PTWG      + LPTWG * Inv_L     + WPTWG * Inv_W     + PPTWG * Inv_WL;
    PDIBLC_i    = PDIBLC    + LPDIBLC * Inv_L   + WPDIBLC * Inv_W   + PPDIBLC * Inv_WL;
    PDIBLCB_i   = PDIBLCB   + LPDIBLCB * Inv_L  + WPDIBLCB * Inv_W  + PPDIBLCB * Inv_WL;
    PSCBE1_i    = PSCBE1    + LPSCBE1 * Inv_L   + WPSCBE1 * Inv_W   + PPSCBE1 * Inv_WL;
    PSCBE2_i    = PSCBE2    + LPSCBE2 * Inv_L   + WPSCBE2 * Inv_W   + PPSCBE2 * Inv_WL;
    PDITS_i     = PDITS     + LPDITS * Inv_L    + WPDITS * Inv_W    + PPDITS * Inv_WL;
    PDITSD_i    = PDITSD    + LPDITSD * Inv_L   + WPDITSD * Inv_W   + PPDITSD * Inv_WL;
    FPROUT_i    = FPROUT    + LFPROUT * Inv_L   + WFPROUT * Inv_W   + PFPROUT * Inv_WL;
    PVAG_i      = PVAG      + LPVAG * Inv_L     + WPVAG * Inv_W     + PPVAG * Inv_WL;
    VSAT_i      = VSAT      + LVSAT * Inv_L     + WVSAT * Inv_W     + PVSAT * Inv_WL;
    PSAT_i      = PSAT      + LPSAT * Inv_L     + WPSAT * Inv_W     + PPSAT * Inv_WL;
    VSATCV_i    = VSATCV    + LVSATCV * Inv_L   + WVSATCV * Inv_W   + PVSATCV * Inv_WL;
    CF_i        = CF        + LCF * Inv_L       + WCF * Inv_W       + PCF * Inv_WL;
    CGSL_i      = CGSL      + LCGSL * Inv_L     + WCGSL * Inv_W     + PCGSL * Inv_WL;
    CGDL_i      = CGDL      + LCGDL * Inv_L     + WCGDL * Inv_W     + PCGDL * Inv_WL;
    CKAPPAS_i   = CKAPPAS   + LCKAPPAS * Inv_L  + WCKAPPAS * Inv_W  + PCKAPPAS * Inv_WL;
    CKAPPAD_i   = CKAPPAD   + LCKAPPAD * Inv_L  + WCKAPPAD * Inv_W  + PCKAPPAD * Inv_WL;

    ALPHA0_i    = ALPHA0    + Inv_L * LALPHA0   + Inv_W * WALPHA0   + Inv_WL * PALPHA0;
    BETA0_i     = BETA0     + Inv_L * LBETA0    + Inv_W * WBETA0    + Inv_WL * PBETA0;

    AGIDL_i     = AGIDL     + Inv_L * LAGIDL    + Inv_W  * WAGIDL   + Inv_WL * PAGIDL;
    BGIDL_i     = BGIDL     + Inv_L * LBGIDL    + Inv_W  * WBGIDL   + Inv_WL * PBGIDL;
    CGIDL_i     = CGIDL     + Inv_L * LCGIDL    + Inv_W  * WCGIDL   + Inv_WL * PCGIDL;
    EGIDL_i     = EGIDL     + Inv_L * LEGIDL    + Inv_W  * WEGIDL   + Inv_WL * PEGIDL;
    AGISL_i     = AGISL     + Inv_L * LAGISL    + Inv_W  * WAGISL   + Inv_WL * PAGISL;
    BGISL_i     = BGISL     + Inv_L * LBGISL    + Inv_W  * WBGISL   + Inv_WL * PBGISL;
    CGISL_i     = CGISL     + Inv_L * LCGISL    + Inv_W  * WCGISL   + Inv_WL * PCGISL;
    EGISL_i     = EGISL     + Inv_L * LEGISL    + Inv_W  * WEGISL   + Inv_WL * PEGISL;

    UTE_i       = UTE       + Inv_L * LUTE      + Inv_W  * WUTE     + Inv_WL * PUTE;
    UA1_i       = UA1       + Inv_L * LUA1      + Inv_W  * WUA1     + Inv_WL * PUA1;
    UC1_i       = UC1       + Inv_L * LUC1      + Inv_W  * WUC1     + Inv_WL * PUC1;
    UD1_i       = UD1       + Inv_L * LUD1      + Inv_W  * WUD1     + Inv_WL * PUD1;
    UCSTE_i     = UCSTE     + Inv_L * LUCSTE    + Inv_W  * WUCSTE   + Inv_WL * PUCSTE;
    PRT_i       = PRT       + Inv_L * LPRT      + Inv_W  * WPRT     + Inv_WL * PPRT;
    AT_i        = AT        + Inv_L * LAT       + Inv_W  * WAT      + Inv_WL * PAT;
    PTWGT_i     = PTWGT     + Inv_L * LPTWGT    + Inv_W  * WPTWGT   + Inv_WL * PPTWGT;
    IIT_i       = IIT       + Inv_L * LIIT      + Inv_W  * WIIT     + Inv_WL * PIIT;
    TGIDL_i     = TGIDL     + Inv_L * LTGIDL    + Inv_W  * WTGIDL   + Inv_WL * PTGIDL;
    IGT_i       = IGT       + Inv_L * LIGT      + Inv_W  * WIGT     + Inv_WL * PIGT;

    AIGBINV_i   = AIGBINV   + Inv_L * LAIGBINV  + Inv_W * WAIGBINV  + Inv_WL * PAIGBINV;
    BIGBINV_i   = BIGBINV   + Inv_L * LBIGBINV  + Inv_W * WBIGBINV  + Inv_WL * PBIGBINV;
    CIGBINV_i   = CIGBINV   + Inv_L * LCIGBINV  + Inv_W * WCIGBINV  + Inv_WL * PCIGBINV;
    EIGBINV_i   = EIGBINV   + Inv_L * LEIGBINV  + Inv_W * WEIGBINV  + Inv_WL * PEIGBINV;
    NIGBINV_i   = NIGBINV   + Inv_L * LNIGBINV  + Inv_W * WNIGBINV  + Inv_WL * PNIGBINV;
    AIGBACC_i   = AIGBACC   + Inv_L * LAIGBACC  + Inv_W * WAIGBACC  + Inv_WL * PAIGBACC;
    BIGBACC_i   = BIGBACC   + Inv_L * LBIGBACC  + Inv_W * WBIGBACC  + Inv_WL * PBIGBACC;
    CIGBACC_i   = CIGBACC   + Inv_L * LCIGBACC  + Inv_W * WCIGBACC  + Inv_WL * PCIGBACC;
    NIGBACC_i   = NIGBACC   + Inv_L * LNIGBACC  + Inv_W * WNIGBACC  + Inv_WL * PNIGBACC;
    AIGC_i      = AIGC      + Inv_L * LAIGC     + Inv_W * WAIGC     + Inv_WL * PAIGC;
    BIGC_i      = BIGC      + Inv_L * LBIGC     + Inv_W * WBIGC     + Inv_WL * PBIGC;
    CIGC_i      = CIGC      + Inv_L * LCIGC     + Inv_W * WCIGC     + Inv_WL * PCIGC;
    AIGS_i      = AIGS      + Inv_L * LAIGS     + Inv_W * WAIGS     + Inv_WL * PAIGS;
    BIGS_i      = BIGS      + Inv_L * LBIGS     + Inv_W * WBIGS     + Inv_WL * PBIGS;
    CIGS_i      = CIGS      + Inv_L * LCIGS     + Inv_W * WCIGS     + Inv_WL * PCIGS;
    AIGD_i      = AIGD      + Inv_L * LAIGD     + Inv_W * WAIGD     + Inv_WL * PAIGD;
    BIGD_i      = BIGD      + Inv_L * LBIGD     + Inv_W * WBIGD     + Inv_WL * PBIGD;
    CIGD_i      = CIGD      + Inv_L * LCIGD     + Inv_W * WCIGD     + Inv_WL * PCIGD;
    POXEDGE_i   = POXEDGE   + Inv_L * LPOXEDGE  + Inv_W * WPOXEDGE  + Inv_WL * PPOXEDGE;
    DLCIG_i     = DLCIG     + Inv_L * LDLCIG    + Inv_W * WDLCIG    + Inv_WL * PDLCIG;
    DLCIGD_i    = DLCIGD    + Inv_L * LDLCIGD   + Inv_W * WDLCIGD   + Inv_WL * PDLCIGD;
    NTOX_i      = NTOX      + Inv_L * LNTOX     + Inv_W * WNTOX     + Inv_WL * PNTOX;

    // Geometrical scaling
    T0 = NDEPL1 * max( pow(Inv_L, NDEPLEXP1) - pow(Inv_Llong, NDEPLEXP1), 0) + NDEPL2 * max( pow(Inv_L, NDEPLEXP2) - pow(Inv_Llong, NDEPLEXP2), 0);
    T1 = NDEPW * max( pow(Inv_W, NDEPWEXP) - pow(Inv_Wwide, NDEPWEXP), 0) + NDEPWL * pow(Inv_W * Inv_L, NDEPWLEXP);
    NDEP_i = NDEP_i * (1.0 + T0 + T1);

    T0 = NFACTORL * max( pow(Inv_L, NFACTORLEXP) - pow(Inv_Llong, NFACTORLEXP), 0);
    T1 = NFACTORW * max( pow(Inv_W, NFACTORWEXP) - pow(Inv_Wwide, NFACTORWEXP), 0) + NFACTORWL * pow(Inv_L * Inv_W, NFACTORWLEXP);
    NFACTOR_i = NFACTOR_i * (1.0 + T0 + T1);

    CDSCD_i = CDSCD_i * (1.0 + CDSCDL * max( pow(Inv_L, CDSCDLEXP) - pow(Inv_Llong, CDSCDLEXP), 0) );
    CDSCB_i = CDSCB_i * (1.0 + CDSCBL * max( pow(Inv_L, CDSCBLEXP) - pow(Inv_Llong, CDSCBLEXP), 0) );

    if (U0LEXP > 0) begin
        U0_i = U0_i * (1.0 - U0L * max( pow(Inv_L, U0LEXP) - pow(Inv_Llong, U0LEXP), 0));
    end else
        U0_i = U0_i * (1.0 - U0L);

    T0 = UAL * max( pow(Inv_L, UALEXP) - pow(Inv_Llong, UALEXP), 0);
    T1 = UAW * max( pow(Inv_W, UAWEXP) - pow(Inv_Wwide, UAWEXP), 0) + UAWL * pow(Inv_L * Inv_W, UAWLEXP);
    UA_i = UA_i * (1.0 + T0 + T1);

    T0 = EUL * max( pow(Inv_L, EULEXP) - pow(Inv_Llong, EULEXP), 0);
    T1 = EUW * max( pow(Inv_W, EUWEXP) - pow(Inv_Wwide, EUWEXP), 0) + EUWL * pow(Inv_L * Inv_W, EUWLEXP);
    EU_i = EU_i * (1.0 + T0 + T1);

    UD_i = UD_i * (1.0 + UDL * max( pow(Inv_L, UDLEXP) - pow(Inv_Llong, UDLEXP), 0));
    T0 = UCL * max( pow(Inv_L, UCLEXP) - pow(Inv_Llong, UCLEXP), 0);
    T1 = UCW * max( pow(Inv_W, UCWEXP) - pow(Inv_Wwide, UCWEXP), 0) + UCWL * pow(Inv_L * Inv_W, UCWLEXP);
    UC_i = UC_i * (1.0 + T0 + T1);
    if (UCS_i < 1.0)
        UCS_i = 1.0;
    else if (UCS_i > 2.0)
        UCS_i = 2.0;

    ETA0_i = ETA0_i * max( pow(Inv_L, DSUB) - pow(Inv_Llong, DSUB), 0);
    ETAB_i = ETAB_i * max( pow(Inv_L, ETABEXP) - pow(Inv_Llong, ETABEXP), 0);
    PDIBLC_i = PDIBLC_i * ( 1.0 + PDIBLCL * max( pow(Inv_L, PDIBLCLEXP) - pow(Inv_Llong, PDIBLCLEXP), 0));

    T0 = DELTA_i * (1.0 + DELTAL * max( pow(Inv_L, DELTALEXP) - pow(Inv_Llong, DELTALEXP), 0));
    DELTA_i = min(T0, 0.5);

    FPROUT_i = FPROUT_i * (1.0 + FPROUTL * max( pow(Inv_L, FPROUTLEXP) - pow(Inv_Llong, FPROUTLEXP), 0));
    PCLM_i = PCLM_i * (1.0 + PCLML * max( pow(Inv_L, PCLMLEXP) - pow(Inv_Llong, PCLMLEXP), 0));
    PCLM_i = max(PCLM_i,0);

    T0 = VSATL * max( pow(Inv_L, VSATLEXP) - pow(Inv_Llong, VSATLEXP), 0);
    T1 = VSATW * max( pow(Inv_W, VSATWEXP) - pow(Inv_Wwide, VSATWEXP), 0) + VSATWL * pow(Inv_L * Inv_W, VSATWLEXP);
    VSAT_i = VSAT_i * (1.0 + T0 + T1);

    PSAT_i = max(PSAT_i * (1.0 + PSATL * max( pow(Inv_L, PSATLEXP) - pow(Inv_Llong, PSATLEXP), 0)), 0.25);
    PTWG_i = PTWG_i * (1.0 + PTWGL * max( pow(Inv_L, PTWGLEXP) - pow(Inv_Llong, PTWGLEXP), 0));

    ALPHA0_i = ALPHA0_i * (1.0 + ALPHA0L * max( pow(Inv_L, ALPHA0LEXP) - pow(Inv_Llong, ALPHA0LEXP), 0));

    AGIDL_i = AGIDL_i * (1.0 + AGIDLL * Inv_L + AGIDLW * Inv_W);
    AGISL_i = AGISL_i * (1.0 + AGISLL * Inv_L + AGISLW * Inv_W);

    AIGC_i = AIGC_i * (1.0 + AIGCL * Inv_L + AIGCW * Inv_W);
    AIGS_i = AIGS_i * (1.0 + AIGSL * Inv_L + AIGSW * Inv_W);
    AIGD_i = AIGD_i * (1.0 + AIGDL * Inv_L + AIGDW * Inv_W);
    PIGCD_i = PIGCD * (1.0 + PIGCDL * Inv_L);

    T0 = NDEPCVL1 * max( pow(Inv_Lact, NDEPCVLEXP1) - pow(Inv_Llong, NDEPCVLEXP1), 0) + NDEPCVL2 * max( pow(Inv_Lact, NDEPCVLEXP2) - pow(Inv_Llong, NDEPCVLEXP2), 0);
    T1 = NDEPCVW * max( pow(Inv_Wact, NDEPCVWEXP) - pow(Inv_Wwide, NDEPCVWEXP), 0) + NDEPCVWL * pow(Inv_Wact * Inv_Lact, NDEPCVWLEXP);
    NDEPCV_i = NDEPCV_i * (1.0 + T0 + T1);

    T0 = VFBCVL * max( pow(Inv_Lact, VFBCVLEXP) - pow(Inv_Llong, VFBCVLEXP), 0);
    T1 = VFBCVW * max( pow(Inv_Wact, VFBCVWEXP) - pow(Inv_Wwide, VFBCVWEXP), 0) + VFBCVWL * pow(Inv_L * Inv_W, VFBCVWLEXP);
    VFBCV_i = VFBCV_i * (1.0 + T0 + T1);

    T0 = VSATCVL * max( pow(Inv_Lact, VSATCVLEXP) - pow(Inv_Llong, VSATCVLEXP), 0);
    T1 = VSATCVW * max( pow(Inv_W, VSATCVWEXP) - pow(Inv_Wwide, VSATCVWEXP), 0) + VSATCVWL * pow(Inv_L * Inv_W, VSATCVWLEXP);
    VSATCV_i = VSATCV_i * (1.0 + T0 + T1);
    PCLMCV_i = PCLMCV_i * (1.0 + PCLMCVL * max( pow(Inv_Lact, PCLMCVLEXP) - pow(Inv_Llong, PCLMCVLEXP), 0));
    PCLMCV_i = max(PCLMCV_i,0);

    T0 = K2L * max( pow(Inv_L, K2LEXP) - pow(Inv_Llong, K2LEXP), 0);
    T1 = K2W * max( pow(Inv_W, K2WEXP) - pow(Inv_Wwide, K2WEXP), 0) + K2WL * pow(Inv_L * Inv_W, K2WLEXP);
    K2_i = K2_i * (1.0 + T0 + T1);

    PRWB_i = PRWB_i * (1.0 + PRWBL * max( pow(Inv_L, PRWBLEXP) - pow(Inv_Llong, PRWBLEXP), 0));

    //Global Scaling parameters for Temperature
    UTE_i = UTE_i * (1.0 + Inv_L * UTEL);
    UA1_i = UA1_i * (1.0 + Inv_L * UA1L);
    UD1_i = UD1_i * (1.0 + Inv_L * UD1L);
    AT_i = AT_i * (1.0 + Inv_L * ATL);
    PTWGT_i = PTWGT_i * (1.0 + Inv_L * PTWGTL);

`ifdef __RDSMOD__
        if (RDSMOD != 0) begin
            RSW_i = RSW_i * (1.0 + RSWL * max( pow(Inv_L, RSWLEXP) - pow(Inv_Llong, RSWLEXP), 0));
            RDW_i = RDW_i * (1.0 + RDWL * max( pow(Inv_L, RDWLEXP) - pow(Inv_Llong, RDWLEXP), 0));
        end else begin
`endif
        RDSW_i = RDSW_i * (1.0 + RDSWL * max( pow(Inv_L, RDSWLEXP) - pow(Inv_Llong, RDSWLEXP),0));
`ifdef __RDSMOD__
        end
`else
            if (RDSMOD != 0)
                $strobe("[BSIM6] Although the model selector RDSMOD is set to 1, the external source/drain resistance model is not activated in the Verilog-A code.  Please uncomment \"`define __RDSMOD__\" in the beginning of the Verilog-A code.");
`endif

        // Parameter Checking
        if (NSD_i <= 0) begin
            $strobe("Fatal: NSD_i = %e is non-positive.", NSD_i);
            $finish(0);
        end
        if (NDEP_i <= 0) begin
            $strobe("Fatal: NDEP_i = %e is non-positive.", NDEP_i);
            $finish(0);
        end
        if (NDEPCV_i <= 0) begin
            $strobe("Fatal: NDEPCV_i = %e is non-positive.", NDEPCV_i);
            $finish(0);
        end
        if (IGBMOD != 0) begin
            if (NIGBINV_i <= 0) begin
                $strobe("Fatal: NIGBINV_i = %e is non-positive.", NIGBINV_i);
                $finish(0);
            end
            if (NIGBACC_i <= 0) begin
                $strobe("Fatal: NIGBACC_i = %e is non-positive.", NIGBACC_i);
                $finish(0);
            end
        end
        if (IGCMOD != 0) begin
            if (POXEDGE_i <= 0) begin
                $strobe("Fatal: POXEDGE_i = %e is non-positive.", POXEDGE_i);
                $finish(0);
            end
        end

        //* initialize variables used in geometry macros
        nuEndD = 0; nuEndS = 0; Rend = 0; Rint = 0;

        //* process drain series resistance
        DMCGeff = DMCG - DMCGT;
        DMCIeff = DMCI;
        DMDGeff = DMDG - DMCGT;

        if (RSH > 0) begin
            if (!$param_given(NRD)&& (RGEOMOD != 0))
                `BSIM6RdseffGeo(NF, GEOMOD, RGEOMOD, MINZ, Weff, RSH, DMCGeff, DMCIeff, DMDGeff, 0, Rtot)
        end

        /* process source series resistance */
        if (RSH > 0) begin
            if (!$param_given(NRS)&& (RGEOMOD != 0))
                `BSIM6RdseffGeo(NF, GEOMOD, RGEOMOD, MINZ, Weff, RSH, DMCGeff, DMCIeff, DMDGeff, 1, Rtot)
        end

        //* Processing S/D resistance and conductance below */
        if ($param_given(NRS)) begin
            RSourceGeo = RSH * NRS;
        end else if (RGEOMOD > 0) begin
            `BSIM6RdseffGeo(NF, GEOMOD, RGEOMOD, MINZ, Weff, RSH, DMCGeff, DMCIeff, DMDGeff, 1, RSourceGeo)
        end else
            RSourceGeo = 0.0;

        if ($param_given(NRD))
            RDrainGeo = RSH * NRD;
        else if (RGEOMOD > 0) begin
            `BSIM6RdseffGeo(NF, GEOMOD, RGEOMOD, MINZ, Weff, RSH, DMCGeff, DMCIeff, DMDGeff, 0, RDrainGeo)
        end else
            RDrainGeo = 0.0;

        /* End of Rsd processing */

        // Clamping of Source/Drain Resistances
        if (RSourceGeo <= 1.0e-3) RSourceGeo = 1.0e-3;
        if (RDrainGeo  <= 1.0e-3) RDrainGeo  = 1.0e-3;

`ifdef __RDSMOD__
            if (RDSMOD != 0) begin
                if (RSWMIN_i <= 0) RSWMIN_i = 0;
                if (RDWMIN_i <= 0) RDWMIN_i = 0;
                if (RSW_i <= 0) RSW_i = 0;
                if (RDW_i <= 0) RDW_i = 0;
            end else begin
`endif
            if (RDSWMIN_i <= 0) RDSWMIN_i = 0;
            if (RDSW_i <= 0) RDSW_i = 0;
`ifdef __RDSMOD__
            end
`endif
        // End - Clamping of Source/Drain Resistances

`ifdef __RBODYMOD__
            //Body resistance network
            Grbsb=0.0; Grbdb=0.0; Grbpb=0.0; Grbps=0.0; Grbpd=0.0;//Initialization
            if (RBODYMOD != 0) begin
                Lnl = ln(Leff * 1.0e6);
                Lnw = ln(Weff * 1.0e6);
                Lnnf = ln(NF);
                Bodymode = 5;
                Rbpb=RBPB;
                Rbpd=RBPD;
                Rbps=RBPS;
                Rbdb=RBDB;
                Rbsb=RBSB;

                if ( !$param_given(RBPS0) || !$param_given(RBPD0))
                    Bodymode = 1;
                else if ( !$param_given(RBSBX0) && !$param_given(RBSBY0) || !$param_given(RBDBX0) && !$param_given(RBDBY0) )
                    Bodymode = 3;

                if (RBODYMOD == 2) begin
                    if (Bodymode == 5) begin
                        Rbsbx = RBSBX0 * exp( RBSDBXL * Lnl + RBSDBXW * Lnw + RBSDBXNF * Lnnf );
                        Rbsby = RBSBY0 * exp( RBSDBYL * Lnl + RBSDBYW * Lnw + RBSDBYNF * Lnnf );
                        Rbsb = Rbsbx * Rbsby / (Rbsbx + Rbsby);
                        Rbdbx =  RBDBX0 * exp( RBSDBXL * Lnl + RBSDBXW * Lnw + RBSDBXNF * Lnnf );
                        Rbdby =  RBDBY0 * exp( RBSDBYL * Lnl + RBSDBYW * Lnw + RBSDBYNF * Lnnf );
                        Rbdb = Rbdbx * Rbdby / (Rbdbx + Rbdby);
                    end
                    if ((Bodymode == 3)|| (Bodymode == 5)) begin
                        Rbps = RBPS0 * exp( RBPSL * Lnl + RBPSW * Lnw + RBPSNF * Lnnf );
                        Rbpd = RBPD0 * exp( RBPDL * Lnl + RBPDW * Lnw + RBPDNF * Lnnf );
                    end
                    Rbpbx =  RBPBX0 * exp( RBPBXL * Lnl + RBPBXW * Lnw + RBPBXNF * Lnnf );
                    Rbpby =  RBPBY0 * exp( RBPBYL * Lnl + RBPBYW * Lnw + RBPBYNF * Lnnf );
                    Rbpb = Rbpbx*Rbpby/(Rbpbx + Rbpby);
                end

                if ((RBODYMOD == 1 ) || ((RBODYMOD == 2 ) && (Bodymode == 5)) ) begin
                    if (Rbdb < 1.0e-3)
                        Grbdb = 1.0e3; /* in mho */
                    else
                        Grbdb = GBMIN + 1.0 / Rbdb;
                    if (Rbpb < 1.0e-3)
                        Grbpb = 1.0e3;
                    else
                        Grbpb = GBMIN + 1.0 / Rbpb;
                    if (Rbps < 1.0e-3)
                        Grbps = 1.0e3;
                    else
                        Grbps = GBMIN + 1.0 / Rbps;
                    if (Rbsb < 1.0e-3)
                        Grbsb = 1.0e3;
                    else
                        Grbsb = GBMIN + 1.0 / Rbsb;
                    if (Rbpd < 1.0e-3)
                        Grbpd = 1.0e3;
                    else
                        Grbpd = GBMIN + 1.0 / Rbpd;
                end else if ((RBODYMOD == 2) && (Bodymode == 3)) begin
                    Grbdb  =  GBMIN;
                    Grbsb  =  GBMIN;
                    if (Rbpb < 1.0e-3)
                        Grbpb = 1.0e3;
                    else
                        Grbpb = GBMIN + 1.0 / Rbpb;
                    if (Rbps < 1.0e-3)
                        Grbps = 1.0e3;
                    else
                        Grbps = GBMIN + 1.0 / Rbps;
                    if (Rbpd < 1.0e-3)
                        Grbpd = 1.0e3;
                    else
                        Grbpd = GBMIN + 1.0 / Rbpd;
                end else if ((RBODYMOD == 2) && (Bodymode == 1)) begin
                    Grbdb  =  GBMIN;
                    Grbsb  =  GBMIN;
                    Grbps  =  1.0e3;
                    Grbpd  =  1.0e3;
                    if (Rbpb < 1.0e-3)
                        Grbpb = 1.0e3;
                    else
                        Grbpb = GBMIN + 1.0 / Rbpb;
                end
            end
`else
            if (RBODYMOD != 0)
                $strobe("[BSIM6] Although the model selector RBODYMOD is set to %d, the body resistance model is not activated in the Verilog-A code.  Please uncomment \"`define __RBODYMOD__\" in the beginning of the Verilog-A code.", RBODYMOD);
`endif

        // Gate process resistance
`ifdef __RGATEMOD__
            Grgeltd = RSHG * (XGW + Weffcj / 3.0 / NGCON)/ ( NGCON * NF * (Lnew - XGL));
            if (Grgeltd > 0.0)
                Grgeltd = 1.0 / Grgeltd;
            else begin
                Grgeltd = 1.0e3; /* mho */
                if (RGATEMOD != 0)
                    `STROBE("Warning: (instance %M) The gate conductance reset to 1.0e3 mho.");
            end
`else
            if (RGATEMOD != 0)
                $strobe("[BSIM6] Although the model selector RGATEMOD is set to %d, the gate resistance model is not activated in the Verilog-A code.  Please uncomment \"`define __RGATEMOD__\" in the beginning of the Verilog-A code.", RGATEMOD);
`endif

        T0 = TOXE * TOXE;
        T1 = TOXE * POXEDGE_i;
        T2 = T1 * T1;
        ToxRatio = exp(NTOX_i * ln(TOXREF / TOXE))/ T0;
        ToxRatioEdge = exp(NTOX_i * ln(TOXREF / T1)) /T2;

        Aechvb = (TYPE == `ntype) ? 4.97232e-7 : 3.42537e-7;
        Bechvb = (TYPE == `ntype) ? 7.45669e11 : 1.16645e12;
        AechvbEdge = Aechvb * Weff * ToxRatioEdge;
        BechvbEdge = -Bechvb * TOXE * POXEDGE_i;
        Aechvb = Aechvb * ( Weff * Leff * ToxRatio);
        Bechvb = Bechvb * ( -TOXE);

        //***** Temperature Dependent Calculations Begin Here *****//

        if (TNOM <= -`P_CELSIUS0) begin
            T0 = `REFTEMP - `P_CELSIUS0;
            $strobe("Warning: TNOM = %e C <= %e C. Setting TNOM to %e C.", TNOM, -`P_CELSIUS0, T0);
            Tnom = `REFTEMP;
        end else begin
            Tnom = TNOM + `P_CELSIUS0;
        end
        DevTemp = $temperature + DTEMP;

        Vt = $vt(DevTemp);
        inv_Vt  = 1.0/Vt;

        TRatio = DevTemp / Tnom;
        delTemp = DevTemp - Tnom;
        Vtm = `KboQ * DevTemp;
        Vtm0 = `KboQ * Tnom;
        Eg = BG0SUB - TBGASUB * DevTemp * DevTemp / (DevTemp + TBGBSUB);
        Eg0 = BG0SUB - TBGASUB * Tnom * Tnom / (Tnom + TBGBSUB);

        T1 = (DevTemp / Tnom) * sqrt(DevTemp / Tnom);
        ni = NI0SUB * T1 * lexp(Eg / (2.0 * Vtm0) - Eg / (2.0 * Vtm));
        phib = ln(NDEP_i / ni);

        if (NGATE_i > 0)
            Vfbsdr = Vt *lln(NGATE_i/NSD_i) + VFBSDOFF;
        else
            Vfbsdr = 0.0;

        // Short Channel Effects
        Phist = max(0.4 + Vt * phib + PHIN_i, 0.4);
        sqrtPhist = sqrt(Phist);
        T1DEP = sqrt(2.0 * epssi / (`q * NDEP_i));
        litl  = sqrt((epssi / epsox) * TOXE * XJ_i);//SCBE Rout

        NFACTOR_t = NFACTOR_i * (1.0 + TNFACTOR * (TRatio - 1.0));
        ETA0_t = ETA0_i * (1.0 + TETA0 * (TRatio - 1.0));

        // Mobility Degradation
        eta_mu = (TYPE != `ntype) ? (`Oneby3 * ETAMOB) : (0.5 * ETAMOB);

        U0_t = U0_i * pow(TRatio, UTE_i);
        UA_t = UA_i * hypsmooth(1.0 + UA1_i*delTemp - 1.0E-6, 1.0E-3);
        UC_t = UC_i * hypsmooth(1.0 + UC1_i*delTemp - 1.0E-6, 1.0E-3);
        UD_t = UD_i * pow(TRatio, UD1_i);
        UCS_t = UCS_i * pow(TRatio, UCSTE_i);

        rdstemp = pow(TRatio, PRT_i);

        VSAT_t = VSAT_i * pow(TRatio, -AT_i);
        if (VSAT_t < 100.0) begin
            $strobe("Warning: VSAT(%f) = %e is less than 100, setting it to 100.", DevTemp, VSAT_t);
            VSAT_t = 100.0;
        end

        VSATCV_t = VSATCV_i * pow(TRatio, -AT_i);
        if (VSATCV_t < 100.0) begin
            $strobe("Warning: VSATCV(%f) = %e is less than 100, setting it to 100.", DevTemp, VSATCV_t);
            VSATCV_t = 100.0;
        end

        DELTA_t = 1.0 / ( hypsmooth((1.0/DELTA_i) * (1.0 + TDELTA * delTemp)-2.0 , 1.0E-3) + 2.0);
        PTWG_t = PTWG_i * hypsmooth(1.0 - PTWGT_i*delTemp - 1.0E-6, 1.0E-3);
        BETA0_t = BETA0_i * pow(TRatio, IIT_i);
        BGIDL_t = BGIDL_i * hypsmooth(1.0 + TGIDL_i * delTemp - 1.0E-6, 1.0E-3);
        BGISL_t = BGISL_i * hypsmooth(1.0 + TGIDL_i * delTemp - 1.0E-6, 1.0E-3);
        igtemp = lexp(IGT_i * lln(TRatio)); //pow(TRatio, IGT_i);

        //***Diode Model temperature Code Start***//
        CJS_t = CJS * hypsmooth(1.0 + TCJ * delTemp - 1.0E-6, 1.0E-3);
        CJD_t = CJD * hypsmooth(1.0 + TCJ * delTemp - 1.0E-6, 1.0E-3);
        CJSWS_t = CJSWS * hypsmooth(1.0 + TCJSW * delTemp - 1.0E-6, 1.0E-3);
        CJSWD_t = CJSWD * hypsmooth(1.0 + TCJSW * delTemp - 1.0E-6, 1.0E-3);
        CJSWGS_t = CJSWGS * hypsmooth(1.0 + TCJSWG * delTemp - 1.0E-6, 1.0E-3);
        CJSWGD_t = CJSWGD * hypsmooth(1.0 + TCJSWG * delTemp - 1.0E-6, 1.0E-3);
        PBS_t = hypsmooth(PBS - TPB * delTemp - 0.01, 1.0E-3) + 0.01;
        PBD_t = hypsmooth(PBD - TPB * delTemp - 0.01, 1.0E-3) + 0.01;
        PBSWS_t = hypsmooth(PBSWS - TPBSW * delTemp - 0.01, 1.0E-3) + 0.01;
        PBSWD_t = hypsmooth(PBSWD - TPBSW * delTemp - 0.01, 1.0E-3) + 0.01;
        PBSWGS_t = hypsmooth(PBSWGS - TPBSWG * delTemp - 0.01, 1.0E-3) + 0.01;
        PBSWGD_t = hypsmooth(PBSWGD - TPBSWG * delTemp - 0.01, 1.0E-3) + 0.01;

        T0 = Eg0 / Vtm0 - Eg / Vtm;
        T1 = lln(TRatio);
        T3 = lexp((T0 + XTIS * T1) / NJS);
        JSS_t = JSS * T3;
        JSWS_t = JSWS * T3;
        JSWGS_t = JSWGS * T3;
        T3 = lexp((T0 + XTID * T1) / NJD);
        JSD_t = JSD * T3;
        JSWD_t = JSWD * T3;
        JSWGD_t = JSWGD * T3;
        JTSS_t = JTSS * lexp(Eg0 * XTSS * (TRatio - 1.0) / Vtm);
        JTSSWS_t = JTSSWS * lexp(Eg0 * XTSSWS * (TRatio - 1.0) / Vtm);
        JTSSWGS_t = JTSSWGS * (sqrt(JTWEFF / W) + 1.0) * lexp(Eg0 * XTSSWGS * (TRatio - 1) / Vtm);
        JTSD_t = JTSD * lexp(Eg0 * XTSD * (TRatio - 1.0) / Vtm);
        JTSSWD_t = JTSSWD * lexp(Eg0 * XTSSWD * (TRatio - 1.0) / Vtm);
        JTSSWGD_t = JTSSWGD * (sqrt(JTWEFF / W) + 1.0) * lexp(Eg0 * XTSSWGD * (TRatio - 1) / Vtm);

        //All NJT*'s smoothed to 0.01 to prevent divide by zero / negative values
        NJTS_t = hypsmooth(NJTS * (1.0 + TNJTS * (TRatio-1.0)) - 0.01, 1.0E-3) + 0.01;
        NJTSSW_t = hypsmooth(NJTSSW * (1.0 + TNJTSSW * (TRatio-1.0)) - 0.01, 1.0E-3) + 0.01;
        NJTSSWG_t = hypsmooth(NJTSSWG * (1.0 + TNJTSSWG * (TRatio-1.0)) - 0.01, 1.0E-3) + 0.01;
        NJTSD_t = hypsmooth(NJTSD * (1.0 + TNJTSD * (TRatio-1.0)) - 0.01, 1.0E-3) + 0.01;
        NJTSSWD_t = hypsmooth(NJTSSWD * (1.0 + TNJTSSWD * (TRatio-1.0)) - 0.01, 1.0E-3) + 0.01;
        NJTSSWGD_t = hypsmooth(NJTSSWGD * (1.0 + TNJTSSWGD * (TRatio-1.0)) - 0.01, 1.0E-3) + 0.01;
        //***Diode Model temperature Code End***//

        // Source-side junction current
        PSeff = 0;
        if ($param_given(PS))
            if (PERMOD == 0) begin
            PSeff = PS; // PS does not include gate-edge perimeter
        end else begin
            PSeff = max(PS - Weffcj * NF, 0.0); // PS includes gate-edge perimeter
        end

        Isbs = AS * JSS_t + PSeff * JSWS_t + Weffcj * NF * JSWGS_t;
        if (Isbs > 0.0) begin
            Nvtms = Vtm * NJS;
            XExpBVS = lexp(-BVS / Nvtms) * XJBVS;
            T2 = max(IJTHSFWD / Isbs, 10.0);
            Tb = 1.0 + T2 - XExpBVS;
            VjsmFwd = Nvtms * lln(0.5 * (Tb + sqrt(Tb * Tb + 4 * XExpBVS)));
            T0 = lexp(VjsmFwd / Nvtms);
            IVjsmFwd = Isbs * (T0 - XExpBVS / T0 + XExpBVS - 1.0);
            SslpFwd = Isbs * (T0 + XExpBVS / T0) / Nvtms;
            T2 = hypsmooth(IJTHSREV / Isbs - 10.0, 1.0E-3) + 10.0;
            VjsmRev = -BVS - Nvtms * lln((T2 - 1.0) / XJBVS);
            T1 = XJBVS * lexp(-(BVS + VjsmRev) / Nvtms);
            IVjsmRev = Isbs * (1.0 + T1);
            SslpRev = -Isbs * T1 / Nvtms;
        end else begin
            Nvtms = 0;
            XExpBVS = 0;
            VjsmFwd = 0;
            IVjsmFwd = 0;
            SslpFwd = 0;
            VjsmRev = 0;
            IVjsmRev = 0;
            SslpRev = 0;
        end

        // Drain-side junction current
        PDeff = 0;
        if ($param_given(PD))
            if (PERMOD == 0) begin
            PDeff = PD; // PD does not include gate-edge perimeter
        end else begin
            PDeff = max(PD - Weffcj * NF, 0.0); // PD includes gate-edge perimeter
        end

        Isbd = AD * JSD_t + PDeff * JSWD_t + Weffcj * NF * JSWGD_t;
        if (Isbd > 0.0) begin
            Nvtmd = Vtm * NJD;
            XExpBVD = lexp(-BVD / Nvtmd) * XJBVD;
            T2 = max(IJTHDFWD / Isbd, 10.0);
            Tb = 1.0 + T2 - XExpBVD;
            VjdmFwd = Nvtmd * lln(0.5 * (Tb + sqrt(Tb * Tb + 4 * XExpBVD)));
            T0 = lexp(VjdmFwd / Nvtmd);
            IVjdmFwd = Isbd * (T0 - XExpBVD / T0 + XExpBVD - 1.0);
            DslpFwd = Isbd * (T0 + XExpBVD / T0) / Nvtmd;
            T2 = hypsmooth(IJTHDREV / Isbd - 10.0, 1.0E-3) + 10.0;
            VjdmRev = -BVD - Nvtmd * lln((T2 - 1.0) / XJBVD);
            T1 = XJBVD * lexp(-(BVD + VjdmRev) / Nvtmd);
            IVjdmRev = Isbd * (1.0 + T1);
            DslpRev = -Isbd * T1 / Nvtmd;
        end else begin
            Nvtmd = 0;
            XExpBVD = 0;
            VjdmFwd = 0;
            IVjdmFwd = 0;
            DslpFwd = 0;
            VjdmRev = 0;
            IVjdmRev = 0;
            DslpRev = 0;
        end

        // Junction Capacitance
        Czbs = CJS_t * AS;
        Czbssw = CJSWS_t * PSeff;
        Czbsswg = CJSWGS_t * Weffcj * NF;
        Czbd = CJD_t * AD;
        Czbdsw = CJSWD_t * PDeff;
        Czbdswg = CJSWGD_t * Weffcj * NF;

        //STI Stress Equations

        if (KU0 !=0 || KVSAT !=0 || KVTH0 !=0 || STK2 !=0 || STETA0 !=0) begin
            T0 = pow(L, LLODKU0);
            W_tmp_stress = W + WLOD;
            T1 = pow(W_tmp_stress, WLODKU0);
            tmp1_stress = LKU0 / T0 + WKU0 / T1 + PKU0 / (T0 * T1);
            kstress_u0 = 1.0 + tmp1_stress;

            T0 = pow(L, LLODVTH);
            T1 = pow(W_tmp_stress, WLODVTH);
            tmp1_stress_vth = LKVTH0 / T0 + WKVTH0 / T1 + PKVTH0 / (T0 * T1);
            kstress_vth0 = 1.0 + tmp1_stress_vth;

            T0 = (TRatio - 1.0);
            ku0_temp = kstress_u0 * (1.0 + TKU0 * T0) + 1.0e-9;

            Inv_sa = 0; Inv_sb = 0;//Initialization of for loop
            for (i = 0; i < NF; i = i+1) begin : forloop
                T0 = 1.0 / NF / (SA + 0.5*L + i * (SD +L));
                T1 = 1.0 / NF / (SB + 0.5*L + i * (SD +L));
                Inv_sa = Inv_sa + T0;
                Inv_sb = Inv_sb + T1;
            end

            Inv_saref = 1.0 / (SAREF + 0.5 * L);
            Inv_sbref = 1.0 / (SBREF + 0.5 * L);
            Inv_odref = Inv_saref + Inv_sbref;
            rho_ref = (KU0/ku0_temp)*Inv_odref;
            Inv_od = Inv_sa + Inv_sb ;
            rho = (KU0/ku0_temp)*Inv_od;
            mu0_mult = (1.0 + rho)/(1.0 + rho_ref);
            vsat_mult = (1.0 + rho*KVSAT)/(1.0 + rho_ref*KVSAT);
            vth0_stress = (KVTH0/kstress_vth0)*(Inv_od - Inv_odref);
            k2_stress = (STK2/pow(kstress_vth0,LODK2))*(Inv_od - Inv_odref);
            eta_stress = (STETA0/pow(kstress_vth0,LODETA0))*(Inv_od - Inv_odref);

            U0_t = U0_t * mu0_mult;
            VSAT_t = VSAT_t * vsat_mult;
            K2_i = K2_i + k2_stress;
            ETA0_t = ETA0_t + eta_stress;
        end else begin
            vth0_stress = 0;
        end
        ///End of Stress Effect

        //Well Proximity Effect
        vth0_well = KVTH0WE*(SCA + WEB*SCB + WEC*SCC);
        k2_well = K2WE*(SCA + WEB*SCB + WEC*SCC);
        mu_well = 1.0 + KU0WE*(SCA + WEB*SCB + WEC*SCC);

        U0_t = U0_t * mu_well;
        K2_i = K2_i + k2_well;
        // end of WPE

        // Load Terminal Voltages
        Vg = devsign * V(`IntrinsicGate, `IntrinsicBody);
        Vd = devsign * V(`IntrinsicDrain, `IntrinsicBody);
        Vs = devsign * V(`IntrinsicSource, `IntrinsicBody);
        Vds = Vd - Vs;
        Vsb_noswap = Vs;
        Vdb_noswap = Vd;

`ifdef __RBODYMOD__
            Vbs_jct = devsign * V(sbulk, `IntrinsicSource);//Beta6 modification
            Vbd_jct = devsign * V(dbulk,`IntrinsicDrain);
`else
            Vbs_jct = -Vs;
            Vbd_jct = -Vd;
`endif

        Vgd_noswap = Vg - Vd;
        Vgs_noswap = Vg - Vs;

`ifdef __RGATEMOD__
            Vgd_ov_noswap = devsign * V(`GateEdgeNode, `IntrinsicDrain);
            Vgs_ov_noswap = devsign * V(`GateEdgeNode, `IntrinsicSource);
`else
            Vgd_ov_noswap = Vgd_noswap;
            Vgs_ov_noswap = Vgs_noswap;
`endif

        // ***************************************************
        // Terminal Voltage Conditioning
        // ***************************************************

        // Source-drain Interchange
        sigvds = 1.0;
        if (Vds < 0.0) begin
            sigvds = -1.0;
            Vd = devsign * V(`IntrinsicSource, `IntrinsicBody);
            Vs = devsign * V(`IntrinsicDrain, `IntrinsicBody);
        end

        Vds = Vd - Vs;
        Vdsx = sqrt(Vds*Vds + 0.01) - 0.1;

        Vbsx = -(Vs + 0.5*(Vds-Vdsx));//Vbsx smoothing

        // *** SCE, DIBL, SS degradation effects (Ref: BSIM4 Model)***

        `Smooth(Phist - Vbsx, 0.05, 0.1, PhistVbs)

        sqrtPhistVbs = sqrt(PhistVbs);
        Xdep        = T1DEP * sqrtPhistVbs;
        Cdep        = epssi / Xdep;
        cdsc        = CIT_i + NFACTOR_t + CDSCD_i * Vdsx - CDSCB_i * Vbsx;
        T1          = 1.0 + cdsc/Cox;

        `Smooth(T1, 1.0, 0.05, n) //Limiting n to 1.0

        nVt     = n * Vt;
        inv_nVt = 1.0/nVt;

        dVth_dibl   = -(ETA0_t + ETAB_i*Vbsx) * Vdsx;//Vth Shift for DIBL
        dvth_temp = (KT1 + KT1L / Leff + KT2*Vbsx) * (pow(TRatio,KT1EXP) - 1.0);//Vth shift with temperature

        /* Vth correction for Pocket implant*/
        if (DVTP0_i > 0.0) begin
            T0 = -DVTP1_i * Vdsx;
            if (T0 < -`EXPL_THRESHOLD)
                T2 = `MIN_EXPL;
            else
                T2 = exp(T0);
            T3 = Leff + DVTP0_i * (1.0 + T2);
            dVth_ldop = -nVt * lln(Leff / T3);
        end else
            dVth_ldop = 0;

        T4 = DVTP5_i + DVTP2_i/pow(Leff, DVTP3_i);
        dVth_ldop = dVth_ldop - T4 * tanh(DVTP4_i * Vdsx);

        //Normalization of terminal and flatband voltage by nVt
        vg  = Vg * inv_nVt;
        vs  = Vs * inv_nVt;
        vfb     = VFB_i * inv_nVt;

        dVth_VNUD   = - K2_i*Vbsx;
        Vth_shift   = dVth_dibl + dVth_ldop + dVth_VNUD - dvth_temp + vth0_stress + vth0_well;
        vgfb = vg - vfb - Vth_shift * inv_nVt;

        //Normalized body factor
        gam = sqrt(2.0 * `q * epssi*NDEP_i * inv_nVt)/Cox;
        inv_gam = 1.0/gam;

        // psip: pinch-off voltage
        phib_n  = phib/n;
        `PO_psip(vgfb,gam,0,phib_n,psip)

        `BSIM_q(psip,phib_n,vs,gam,qs) // normalized inversion charge at source end of channel

        // average charge-surf. pot. slope - Ref.: Charge-based MOS Transistor Modeling by C. Enz & E. Vittoz
        `Smooth(psip, 1.0, 2.0, psipclamp)
        sqrtpsip = sqrt(psipclamp);
        psiavg   = psip - 2.0*qs; // source side surf pot.
        `Smooth(psiavg, 1.0, 2.0, T0)
        nq       = 1.0 + gam / (sqrtpsip + sqrt(T0));

        // *** Drain Saturation Voltage ***
        EeffFactor = 1.0e-8 / (epsratio * TOXE);

        T0 = nVt * (vgfb - psip - 2.0*qs*(nq-1.0));
        `Smooth(T0, 0, 0.1, qbs)
        qis = 2.0 * nq * nVt * qs; //Source side qi and qb for Vdsat- normalized to Cox

        Eeffs = EeffFactor * (qbs + eta_mu * qis); // in the unit of MV/cm

        // Ref: BSIM4 Model mobility model
        T2      = pow(0.5 * (1.0 + (qis / qbs)), UCS_t);
        T3      = (UA_t + UC_t*Vbsx) * pow(Eeffs, EU_i) + UD_t / T2;
        Dmobs   = 1.0 + T3;

        WeffWRFactor = 1.0 / (pow(Weff*1.0e6, WR_i) * NF);

`ifdef __RDSMOD__
            if (RDSMOD != 0)
                Rdss = 0.0;
            else begin
`endif
            T0 = 1.0 + PRWG_i * qis;
            T1 = PRWB_i*(sqrtPhistVbs - sqrtPhist);
            T2 = 1.0 / T0 + T1;
            T3 = T2 + sqrt(T2*T2 + 0.01);
            Rdss = (RSourceGeo + RDrainGeo + (RDSWMIN_i + RDSW_i * T3) * WeffWRFactor )* NF * rdstemp;
`ifdef __RDSMOD__
            end
`endif

        T0          = pow(Dmobs, 1.0/PSAT_i);
        if (PSATB<0)
            T1          = 1.0 / (1.0 + PSATB * Vbsx);
        else
            T1          = 1.0 - PSATB * Vbsx;

        T2          = 10.0 *PSATX * qs * T1 / (10.0 *PSATX + qs * T1);
        if (PTWG_t<0)
            LambdaC = 2.0 * ((U0_t / T0) * nVt / (VSAT_t * Leff)) * (1.0/(1.0-PTWG_t*T2));
        else
            LambdaC = 2.0 * ((U0_t / T0) * nVt / (VSAT_t * Leff)) * (1.0 + PTWG_t*T2);

        if (Rdss==0) begin// qdsat for external Rds
            // Accurate qdsat derived from consistent I-V
            T0 = 0.5 * LambdaC * (qs*qs + qs) / (1.0 + 0.5 * LambdaC *(1.0 + qs));
            T1 = 2.0 * LambdaC * (qs - T0);
            T2 = sqrt(1.0 + T1*T1);
            ln_T1_T2 = asinh(T1);//used VA function for asinh(T1)=ln(T1 + T2)
            if (T1 != 0)
                T3 =   T2 + (1.0/T1) * ln_T1_T2;
            else
                T3 =   T2 + (1.0/T2) ;

            T4 = T0 * T3 - LambdaC * ((qs*qs + qs) - (T0*T0 + T0) );
            if (T1 != 0)
                T5 = (-2.0 * LambdaC) * (T1*T2 - ln_T1_T2) / (T1*T1);
            else
                T5 = (-2.0 * LambdaC) * (T1/T2) * (T1/T2) *(T1/T2);

            T6 = T0 * T5 + T3 + LambdaC * (2.0*T0 + 1.0);
            T0 = T0 - (T4/T6);

            T1 = 2.0 * LambdaC * (qs - T0);
            T2 = sqrt(1.0 + T1*T1);
            ln_T1_T2 = asinh(T1);
            if (T1 != 0)
                T3 =   T2 + (1.0/T1) * ln_T1_T2 ;
            else
                T3 =   T2 + (1.0/T2) ;

            T4 = T0 * T3 - LambdaC * ((qs*qs + qs) - (T0*T0 + T0) );
            if (T1 != 0)
                T5 = (-2.0 * LambdaC) * (T1*T2 - ln_T1_T2) / (T1*T1);
            else
                T5 = (T1/T2) * (T1/T2) *(T1/T2);

            T6 = T0 * T5 + T3 + LambdaC * (2.0*T0 + 1.0);
            qdsat = T0 - (T4/T6);

        end else begin // qdsat for internal Rds -- Ref. : BSIM4 model
            // Accurate qdsat derived from consistent I-V
            T11 = Weff * 2.0 * nq * Cox * nVt * VSAT_t;
            T12 = T11 * LambdaC * Rdss / (2.0*nVt);
            T0  = 0.5 * LambdaC * (qs*qs + qs) / (1.0 + 0.5 * LambdaC *(1.0 + qs));
            T1  = 2.0 * LambdaC * (qs - T0);
            T2  = sqrt(1.0 + T1*T1);
            ln_T1_T2 = asinh(T1);//used VA function for asinh(T1)=ln(T1 + T2)
            if (T1 != 0)
                T3 =   T2 + (1.0/T1) * ln_T1_T2 ;
            else
                T3 =   T2 + (1.0/T2) ;

            T4  = T0 * T3 + T12 * T0 * (qs + T0 + 1.0) - LambdaC * ((qs*qs + qs) - (T0*T0 + T0) );
            if (T1 != 0)
                T5 = (-2.0 * LambdaC) * (T1*T2 - ln_T1_T2) / (T1*T1);
            else
                T5 = (-2.0 * LambdaC) * (T1/T2) * (T1/T2) *(T1/T2);

            T6  = T0 * T5 + T3 + T12 * (qs + 2.0*T0 + 1.0) + LambdaC * (2.0 * T0 + 1.0);
            T0  = T0 - T4/T6;

            T1  = 2.0 * LambdaC * (qs - T0);
            T2  = sqrt(1.0 + T1*T1);
            ln_T1_T2 = asinh(T1);
            if (T1 != 0)
                T3 =   T2 + (1.0/T1) * ln_T1_T2 ;
            else
                T3 =   T2 + (1.0/T2) ;

            T4  = T0 * T3 + T12 * T0 * (qs + T0 + 1.0) - LambdaC * ((qs*qs + qs) - (T0*T0 + T0) );
            if (T1 != 0)
                T5 = (-2.0 * LambdaC) * (T1*T2 - ln_T1_T2) / (T1*T1);
            else
                T5 = (-2.0 * LambdaC) * (T1/T2) * (T1/T2) *(T1/T2);

            T6  = T0 * T5 + T3 + T12 * (qs + 2.0*T0 + 1.0) + LambdaC * (2.0 * T0 + 1.0);
            qdsat  = T0 - T4/T6;
        end

        vdsat   = psip -2.0*phib_n - (2.0*qdsat + ln( (qdsat*2.0*nq*inv_gam)*((qdsat*2.0*nq*inv_gam) + (gam/(nq-1.0)) ) ));
        Vdsat   = vdsat * nVt;

        // normalized charge qdeff at drain end of channel
        `Smooth(Vdsat - Vs, 0.0, 1e-3, Vdssat) //Vdssat clamped to avoid negative values during transient simulation
        T7      = pow(Vds/Vdssat , 1.0/DELTA_t);
        T8      = pow(1.0+T7, -DELTA_t);
        Vdseff  =  Vds*T8;
        vdeff   = (Vdseff + Vs) * inv_nVt;
        `BSIM_q(psip,phib_n,vdeff,gam,qdeff)

        //*********************************************************
        // Reevaluation of nq to include qdeff --needed for gummel symmetry
        psiavg = psip - qs - qdeff -1.0;
        `Smooth(psiavg, 1.0, 2.0, T0)
        T2 = sqrt(T0);
        nq = 1.0 + gam/(sqrtpsip+T2);
        //Inversion and bulk charge
        DQSD2 = (qs-qdeff)*(qs-qdeff);
        T0 = 1.0 / (1.0 + qs + qdeff);
        T1 = DQSD2 * T0;
        Qb = vgfb -psip - (nq-1.0)*( qs + qdeff + `Oneby3 * T1);
        T2 = `Oneby3*nq;
        T3 = T1*T0;
        Qs = T2*( 2.0*qs + qdeff + 0.5*(1.0+0.8*qs+1.2*qdeff)*T3);
        Qd = T2*( qs + 2.0*qdeff + 0.5*(1.0+1.2*qs+0.8*qdeff)*T3);
        //*********************************************************

        // *** Mobility Degradation (Ref: BSIM4 Model)***
        //Average charges (qba and qia) - normalized to Cox
        `Smooth(nVt*Qb, 0, 0.1, qba)
        qia = nVt*( Qs + Qd);

        Eeffm   = EeffFactor * (qba + eta_mu * qia); // in the unit of MV/cm
        T2      = pow(0.5 * (1.0 + (qia / qba)), UCS_t);
        T3      = (UA_t + UC_t * Vbsx) * pow(Eeffm, EU_i) + UD_t / T2;
        Dmob    = 1.0 + T3;

        // *** Output Conductance Modules ***
        Esat    = 2.0 * VSAT_t / (U0_t / Dmob);
        EsatL   = Esat * Leff;
        if (PVAG_i  > 0)
            PVAGfactor = 1.0 + PVAG_i * qia / EsatL;
        else
            PVAGfactor = 1.0 / (1.0 - PVAG_i * qia / EsatL);

        // Output conductance due to DIBL - Ref: BSIM4 Model
        DIBLfactor  = PDIBLC_i;
        diffVds     = Vds - Vdseff;
        Vgst2Vtm    = qia + 2.0 * nVt;
        if (DIBLfactor > 0) begin
            T3      = Vgst2Vtm / (Vdssat + Vgst2Vtm);
            T4      = 1.0/(1.0 + PDIBLCB_i * Vbsx);
            VaDIBL  = Vgst2Vtm / DIBLfactor * T3 * PVAGfactor * T4;
            Moc     = 1.0 + diffVds / VaDIBL;
        end else begin
            Moc = 1.0;
        end

        // Degradation factor due to pocket implant -- Ref BSIM4
        if (FPROUT_i <= 0.0)
            Fp = 1.0;
        else begin
            T9 = FPROUT_i * sqrt(Leff) / Vgst2Vtm;
            Fp = 1.0 / (1.0 + T9);
        end

        // Channel Length Modulation -- Ref BSIM4
        Vasat = Vdssat + EsatL;
        if (PCLM_i != 0) begin
            if (PCLMG < 0.0)
                T1 = PCLM_i / (1.0 - PCLMG * qia / EsatL)/Fp;
            else
                T1 = PCLM_i * (1.0 + PCLMG * qia / EsatL)/Fp;
            MdL = 1.0 + T1 * lln(1.0 + diffVds / T1 / Vasat);
        end else
            MdL = 1.0;
        Moc = Moc * MdL;

        // Calculate Vadits -- Ref BSIM4
        T1 = lexp(PDITSD_i * Vds);
        if (PDITS_i > 0.0) begin
            T2      = 1.0 + PDITSL * Leff;
            VaDITS  = (1.0 + T2 * T1) / PDITS_i;
            VaDITS  = VaDITS * Fp;
        end else
            VaDITS  = `MAX_EXPL;

        T4  = diffVds / VaDITS;
        T0  = 1.0 + T4;
        Moc = Moc * T0;

        // Calculate Vascbe -- Ref BSIM4
        if (PSCBE2_i > 0.0) begin
            if (diffVds > PSCBE1_i * litl / `EXPL_THRESHOLD) begin
                T0      = PSCBE1_i * litl / diffVds;
                VaSCBE  = Leff * exp(T0) / PSCBE2_i;
            end else
                VaSCBE  = `MAX_EXPL * Leff/PSCBE2_i;
        end else
            VaSCBE = `MAX_EXPL;

        Mscbe   = 1.0 + (diffVds / VaSCBE);
        Moc = Moc * Mscbe;

        // *** S/D series resistance -- Ref: BSIM4 Model
`ifdef __RDSMOD__
            Rsource = 0.0; Rdrain = 0.0; //Initialization
            if (RDSMOD != 0) begin
                Rdsi = 0.0;
                Dr = 1.0;

                // Rs (Source side resistance for all fingers)
                T2      = Vgs_noswap - Vfbsdr;
                T3      = sqrt(T2 * T2 + 0.01);
                Vgs_eff = 0.5 * (T2 + T3);
                T5      = 1.0 + PRWG_i * Vgs_eff;
                T6      = (1.0/T5) + PRWB_i * Vsb_noswap;
                T4      = 0.5 * (T6 + sqrt(T6 * T6 + 0.01));
                Rsource = rdstemp * (RSourceGeo + (RSWMIN_i + RSW_i * T4) * WeffWRFactor);

                // Rd (Drain side resistance for all fingers)
                T2      = Vgd_noswap - Vfbsdr;
                T3      = sqrt(T2 * T2 + 0.01);
                Vgd_eff = 0.5 * (T2 + T3);
                T5      = 1.0 + PRWG_i * Vgd_eff;
                T6      = (1.0/T5) + PRWB_i * Vdb_noswap;
                T4      = 0.5 * (T6 + sqrt(T6 * T6 + 0.01));
                Rdrain  = rdstemp * (RDrainGeo + (RDWMIN_i + RDW_i * T4) * WeffWRFactor);

            end else begin
`endif
            // Ref: (1) BSIM4 Model
            //      (2) "Operation and Modeling of the MOS Transistor" by Yannis Tsividis
            T0 = 1.0 + PRWG_i * qia;//reevaluate for gummel symmetry
            T1 = PRWB_i*(sqrtPhistVbs - sqrtPhist);
            T2 = 1.0 / T0 + T1;
            T3 = 0.5 * (T2 + sqrt(T2*T2 + 0.01));
            Rdsi = rdstemp * (RSourceGeo + RDrainGeo + (RDSWMIN_i + RDSW_i * T3) * WeffWRFactor )* NF ;
            Dr = 1.0 + U0_t * Cox * Weff / Leff * qia * Rdsi;
            Rdrain = 0;
            Rsource = 0;
`ifdef __RDSMOD__
            end
`endif

        // *** Velocity Saturation ***

        T0          = pow(Dmob, 1.0/PSAT_i);
        if (PSATB<0)
            T1          = 1.0 / (1.0 + PSATB * Vbsx);
        else
            T1          = 1.0 - PSATB * Vbsx;

        T2          = 10.0* PSATX * qia * T1 / (10.0 *PSATX + qia * T1);
        if (PTWG_t<0)
            LambdaC = 2.0 * ((U0_t / T0) * nVt / (VSAT_t * Leff)) * (1.0/(1.0- PTWG_t * T2));
        else
            LambdaC = 2.0 * ((U0_t / T0) * nVt / (VSAT_t * Leff)) * (1.0 + PTWG_t * T2);

        T1          = 2.0 * LambdaC * (qs - qdeff);
        T2          = sqrt(1.0 + T1 * T1);
        ln_T1_T2        = asinh(T1);

        if (T1 != 0)
            Dvsat   = 0.5 * ( T2 + (1.0/T1) * asinh(T1) );
        else
            Dvsat   = 0.5 * ( T2 + (1.0/T2) );
        Dptwg       = Dvsat;

        Dtot        = Dmob * Dvsat * Dr;

        ueff = U0_t / Dtot; //Effective Mobility including mobility degradation

        // ***************************************************
        // I-V Equation
        // ***************************************************

        ids = 2.0 * nq * ueff * Weff/Leff * Cox * nVt * nVt *((qs - qdeff)*(1.0 + qs + qdeff)) *Moc;

`ifdef __RGATEMOD__
            /* Calculate Rg */
            Gcrg = 0.0;
            if (RGATEMOD > 1) begin
                //idsovvds= ueff*Weff/Leff*Cox*qia*Moc;
                idsovvds= ueff*Weff/Leff*Cox*qia;
                T9 = XRCRG2 * Vt;
                T0 = T9 * ueff * Weff/Leff * Cox;
                Gcrg = XRCRG1 * NF * (T0 + idsovvds);
                if (RGATEMOD == 2) begin
                    T11 = Grgeltd + Gcrg;
                    Gcrg = Grgeltd * Gcrg / T11;
                end
            end
`endif

        //Impact Ionization Current (Ref: BSIM4 Model)
        if ((ALPHA0_i <= 0.0) || (BETA0_t <= 0.0))
            Iii = 0.0;
        else if (diffVds > BETA0_t / `EXPL_THRESHOLD) begin
            T1 = - BETA0_t / diffVds;
            Iii = ALPHA0_i * diffVds * ids * lexp(T1)/Mscbe;
        end else begin
            Iii = ALPHA0_i * diffVds * ids * `MIN_EXPL/Mscbe;
        end
        III = Iii * devsign *NF;

        // *** Gate Current ***// Ref: BSIM4 Model

        igbinv = 0.0;   igbacc = 0.0;   igb = 0.0;
        igcs = 0.0;     igcd = 0.0;     igs = 0.0;  igd = 0.0;
        //Initialization

        if ((IGCMOD != 0) || (IGBMOD != 0)) begin
            Voxm = nVt * (vgfb -psip + qs + qdeff);
            T1 = sqrt(Voxm*Voxm + 1.0E-4);
            Voxmacc = 0.5*(-Voxm + T1);
            Voxminv = 0.5*( Voxm + T1);

            // Igbinv
            if (IGBMOD != 0) begin
                T1 = Voxmacc / NIGBACC_i / Vt; //representative of Qb in acc
                Vaux_Igbacc = NIGBACC_i * Vt * lln(1 + lexp(-T1));
                T2 = AIGBACC_i - BIGBACC_i * Voxmacc;
                T3 = 1.0 + CIGBACC_i * Voxmacc;
                T4 = -7.45669e11 * TOXE * T2 * T3;
                T5 = lexp (T4);
                T6 = 4.97232e-7;
                igbacc = NF * Weff * Leff * T6 * ToxRatio * Vg * Vaux_Igbacc * T5;
                igbacc = igbacc * igtemp;

                T1 = (Voxminv - EIGBINV_i) / NIGBINV_i / Vt;
                Vaux_Igbinv = NIGBINV_i * Vt * lln(1.0 + lexp(T1));
                T2 = AIGBINV_i - BIGBINV_i * Voxminv;
                T3 = 1.0 + CIGBINV_i * Voxminv;
                T4 = -9.82222e11 * TOXE * T2 * T3;
                T5 = lexp (T4);
                T6 = 3.75956e-7;
                igbinv = NF * Weff * Leff * T6 * ToxRatio * Vg * Vaux_Igbinv * T5;
                igbinv = igbinv * igtemp;
                igb = (igbacc + igbinv);
            end

            if (IGCMOD != 0) begin
                // Igcinv
                T1 = AIGC_i - BIGC_i * Voxminv;
                T2 = 1.0 + CIGC_i * Voxminv;
                T3 = Bechvb * T1 * T2;
                T4 = nq * nVt * (qs + qdeff) * lexp(T3);
                igc0 = NF * Aechvb * T4 * (Vg + 0.5 *Vdsx - 0.5*(Vs+Vd)) * igtemp;

                // Gate-current partitioning
                Vdseffx = sqrt(Vdseff*Vdseff + 0.01) - 0.1;
                T1 = PIGCD_i * Vdseffx;
                T1_exp = lexp(-T1);
                T3 = T1 + T1_exp -1.0 + 1.0E-4;
                T4 = 1.0 - (T1 + 1.0) * T1_exp + 1.0E-4;
                T5 = T1 * T1 + 2.0E-4;
                igcd = igc0 * T4 / T5;
                igcs = igc0 * T3 / T5;

                // Igs
                T2  = Vgs_noswap - Vfbsdr;
                Vgs_eff = sqrt(T2 * T2 + 1.0e-4);
                T1 = AIGS_i - BIGS_i * Vgs_eff;
                T2 = 1.0 + CIGS_i * Vgs_eff;
                T3 = BechvbEdge * T1 * T2;
                T4 = lexp(T3);
                igs_mult = igtemp * NF * AechvbEdge * DLCIG_i;
                if (sigvds > 0)  igs = igs_mult * Vgs_noswap * Vgs_eff * T4;
                else            igd = igs_mult * Vgs_noswap * Vgs_eff * T4;

                // Igd
                T2  = Vgd_noswap - Vfbsdr;
                Vgd_eff     = sqrt(T2 * T2 + 1.0e-4);
                T1 = AIGD_i - BIGD_i * Vgd_eff;
                T2 = 1.0 + CIGD_i * Vgd_eff;
                T3 = BechvbEdge * T1 * T2;
                T4 = lexp(T3);
                igd_mult = igtemp * NF * AechvbEdge * DLCIGD_i;
                if (sigvds > 0)  igd = igd_mult * Vgd_noswap * Vgd_eff * T4;
                else            igs = igd_mult * Vgd_noswap * Vgd_eff * T4;
            end
        end

        IGS = devsign * igs;
        IGD = devsign * igd;
        IGB = devsign * igb;
        IGCS = devsign * igcs;
        IGCD = devsign * igcd;

        // GIDL/GISL current (Ref: BSIM4 Model)
        igisl = 0.0;
        igidl = 0.0;
        if (GIDLMOD != 0) begin
            T0 = epsratio * TOXE;
            // GIDL
            if ((AGIDL_i <= 0.0) || (BGIDL_t <= 0.0) || (CGIDL_i < 0.0)) begin
                T6 = 0.0;
            end else begin
                T1 = (- Vgd_noswap - EGIDL_i + Vfbsdr) / T0;
                T1 =  hypsmooth(T1, 1.0E-2);
                T2 = BGIDL_t / (T1 + 1.0E-3);
                if (CGIDL_i !=0) begin
                    T3 = Vdb_noswap*Vdb_noswap*Vdb_noswap;
                    T4 = CGIDL_i + abs(T3) + 1.0E-9;
                    T5 = hypsmooth(T3/T4, 1.0E-6) - 1.0E-6;
                end else
                    T5 = 1.0;
                T6 = AGIDL_i * Weff * T1 * lexp(-T2) * T5;
            end
            igidl = T6;

            // GISL
            if ((AGISL_i <= 0.0) || (BGISL_t <= 0.0) || (CGISL_i < 0.0)) begin
                T6 = 0.0;
            end else begin
                T1 = (- Vgs_noswap - EGISL_i + Vfbsdr) / T0;
                T1 =  hypsmooth(T1, 1.0E-2);
                T2 = BGISL_t / (T1 + 1.0E-3);
                if (CGISL_i !=0) begin
                    T3 = Vsb_noswap*Vsb_noswap*Vsb_noswap;
                    T4 = CGISL_i + abs(T3) + 1.0E-9;
                    T5 = hypsmooth(T3/T4, 1.0E-6) - 1.0E-6;
                end else
                    T5 = 1.0;
                T6 = AGISL_i * Weff * T1 * lexp(-T2) * T5;
            end
            igisl = T6;
        end // GIDLMOD

        IGIDL = devsign * NF * igidl;
        IGISL = devsign * NF * igisl;

        // Junction Current and Capacitances
        // Source-side junction current
        if (Isbs > 0.0) begin
            if (Vbs_jct < VjsmRev) begin
                T0 = Vbs_jct / Nvtms;
                T1 = lexp(T0) - 1.0;
                T2 = IVjsmRev + SslpRev * (Vbs_jct - VjsmRev);
                Ibs = T1 * T2;
            end else if (Vbs_jct <= VjsmFwd) begin
                T0 = Vbs_jct / Nvtms;
                T1 = (BVS + Vbs_jct) / Nvtms;
                T2 = lexp(-T1);
                Ibs = Isbs * (lexp(T0) + XExpBVS - 1.0 - XJBVS * T2);
            end else
                Ibs = IVjsmFwd + SslpFwd * (Vbs_jct - VjsmFwd);
        end else
            Ibs = 0.0;

        //Source-side junction tunneling current
        if (JTSS_t > 0.0) begin
            if ((VTSS - Vbs_jct) < (VTSS * 1.0e-3)) begin
                T0 = -Vbs_jct / Vtm0 / NJTS_t;
                T1 = lexp(T0 * 1.0e+3) - 1.0;
                Ibs = Ibs - AS * JTSS_t * T1;
            end else begin
                T0 = -Vbs_jct / Vtm0 / NJTS_t;
                T1 = lexp(T0 * VTSS / (VTSS - Vbs_jct)) - 1.0;
                Ibs = Ibs - AS * JTSS_t * T1;
            end
        end
        if (JTSSWS_t > 0.0) begin
            if ((VTSSWS - Vbs_jct) < (VTSSWS * 1.0e-3)) begin
                T0 = -Vbs_jct / Vtm0 / NJTSSW_t;
                T1 = lexp(T0 * 1.0e+3) - 1.0;
                Ibs = Ibs - PSeff * JTSSWS_t * T1;
            end else begin
                T0 = -Vbs_jct / Vtm0 / NJTSSW_t;
                T1 = lexp(T0 * VTSSWS / (VTSSWS - Vbs_jct)) - 1.0;
                Ibs = Ibs - PSeff * JTSSWS_t * T1;
            end
        end
        if (JTSSWGS_t > 0.0) begin
            if ((VTSSWGS - Vbs_jct) < (VTSSWGS * 1.0e-3)) begin
                T0 = -Vbs_jct / Vtm0 / NJTSSWG_t;
                T1 = lexp(T0 * 1.0e+3) - 1.0;
                Ibs = Ibs - Weffcj * NF * JTSSWGS_t * T1;
            end else begin
                T0 = -Vbs_jct / Vtm0 / NJTSSWG_t;
                T1 = lexp(T0 * VTSSWGS / (VTSSWGS - Vbs_jct)) - 1.0;
                Ibs = Ibs - Weffcj * NF * JTSSWGS_t * T1;
            end
        end

        // Drain-side junction current
        if (Isbd > 0.0) begin
            if (Vbd_jct < VjdmRev) begin
                T0 = Vbd_jct / Nvtmd;
                T1 = lexp(T0) - 1.0;
                T2 = IVjdmRev + DslpRev * (Vbd_jct - VjdmRev);
                Ibd = T1 * T2;
            end else if (Vbd_jct <= VjdmFwd) begin
                T0 = Vbd_jct / Nvtmd;
                T1 = (BVD + Vbd_jct) / Nvtmd;
                T2 = lexp(-T1);
                Ibd = Isbd * (lexp(T0) + XExpBVD - 1.0 - XJBVD * T2);
            end else
                Ibd = IVjdmFwd + DslpFwd * (Vbd_jct - VjdmFwd);
        end else
            Ibd = 0.0;

        //Drain-side junction tunneling current
        if (JTSD_t > 0.0) begin
            if ((VTSD - Vbd_jct) < (VTSD * 1.0e-3)) begin
                T0 = -Vbd_jct / Vtm0 / NJTSD_t;
                T1 = lexp(T0 * 1.0e+3) - 1.0;
                Ibd = Ibd - AD * JTSD_t * T1;
            end else begin
                T0 = -Vbd_jct / Vtm0 / NJTSD_t;
                T1 = lexp(T0 * VTSD/ (VTSD - Vbd_jct)) - 1.0;
                Ibd = Ibd - AD * JTSD_t * T1;
            end
        end
        if (JTSSWD_t > 0.0) begin
            if ((VTSSWD - Vbd_jct) < (VTSSWD * 1.0e-3)) begin
                T0 = -Vbd_jct / Vtm0 / NJTSSWD_t;
                T1 = lexp(T0 * 1.0e+3) - 1.0;
                Ibd = Ibd - PDeff * JTSSWD_t * T1;
            end else begin
                T0 = -Vbd_jct / Vtm0 / NJTSSWD_t;
                T1 = lexp(T0 * VTSSWD / (VTSSWD - Vbd_jct)) - 1.0;
                Ibd = Ibd - PDeff * JTSSWD_t * T1;
            end
        end
        if (JTSSWGD_t > 0.0) begin
            if ((VTSSWGD - Vbd_jct) < (VTSSWGD * 1.0e-3)) begin
                T0 = -Vbd_jct / Vtm0 / NJTSSWGD_t;
                T1 = lexp(T0 * 1.0e+3) - 1.0;
                Ibd = Ibd - Weffcj * NF * JTSSWGD_t * T1;
            end else begin
                T0 = -Vbd_jct / Vtm0 / NJTSSWGD_t;
                T1 = lexp(T0 * VTSSWGD / (VTSSWGD - Vbd_jct)) - 1.0;
                Ibd = Ibd - Weffcj * NF * JTSSWGD_t * T1;
            end
        end

        // *** Junction capacitance (!!no swapping !!) ***
        /* Source Bulk Junction */
        if (Czbs > 0.0) begin
            T1 = Vbs_jct/PBS_t;
            if (T1<0.9) begin
                arg = 1.0 - T1;
                if (MJS == 0.5)  sarg = 1.0 / sqrt(arg);
                else             sarg = lexp(-MJS * lln(arg));
                Qbs = PBS_t * Czbs * (1.0 - arg * sarg) / (1.0 - MJS);
            end else begin
                T2 = pow(0.1,-MJS);
                T3 = 1.0/(1.0-MJS);
                T4 = T2 * (T1-1.0) * (5.0*MJS*(T1-1.0) + (1.0+MJS) );
                T5 = T3 * (1.0 - 0.05*MJS*(1.0+MJS)*T2 );
                Qbs = PBS_t * Czbs * (T4 + T5); //Quadratic equation for Qbs when Vbs_jct/PBS_t<=0.9
            end
        end else begin
            Qbs = 0.0;
        end

        if (Czbssw > 0.0) begin
            T1 = Vbs_jct/PBSWS_t;
            if (T1<0.9) begin
                arg = 1.0 - T1;
                if (MJSWS == 0.5)  sarg = 1.0 / sqrt(arg);
                else               sarg = lexp(-MJSWS * lln(arg));
                Qbs = Qbs + PBSWS_t * Czbssw * (1.0 - arg * sarg) / (1.0 - MJSWS);
            end else begin
                T2 = pow(0.1,-MJSWS);
                T3 = 1.0/(1.0-MJSWS);
                T4 = T2 * (T1-1.0) * (5.0*MJSWS*(T1-1.0) + (1.0+MJSWS) );
                T5 = T3 * (1.0 - 0.05*MJSWS*(1.0+MJSWS)*T2 );
                Qbs = Qbs + PBSWS_t * Czbssw * (T4 + T5);
            end
        end

        if (Czbsswg > 0.0) begin
            T1 = Vbs_jct/PBSWGS_t;
            if (T1<0.9) begin
                arg = 1.0 - T1;
                if (MJSWGS == 0.5)  sarg = 1.0 / sqrt(arg);
                else                sarg = lexp(-MJSWGS * lln(arg));
                Qbs = Qbs + PBSWGS_t * Czbsswg * (1.0 - arg * sarg) / (1.0 - MJSWGS);
            end else begin
                T2 = pow(0.1,-MJSWGS);
                T3 = 1.0/(1.0-MJSWGS);
                T4 = T2 * (T1-1.0) * (5.0*MJSWGS*(T1-1.0) + (1.0+MJSWGS) );
                T5 = T3 * (1.0 - 0.05*MJSWGS*(1.0+MJSWGS)*T2 );
                Qbs = Qbs + PBSWGS_t * Czbsswg * (T4 + T5);
            end
        end

        /* Drain Bulk Junction */
        if (Czbd > 0.0) begin
            T1 = Vbd_jct/PBD_t;
            if (T1<0.9) begin
                arg = 1.0 - T1;
                if (MJD == 0.5)  sarg = 1.0 / sqrt(arg);
                else             sarg = lexp(-MJD * lln(arg));
                Qbd = PBD_t * Czbd * (1.0 - arg * sarg) / (1.0 - MJD);
            end else begin
                T2 = pow(0.1,-MJD);
                T3 = 1.0/(1.0-MJD);
                T4 = T2 * (T1-1.0) * (5.0*MJD*(T1-1.0) + (1.0+MJD) );
                T5 = T3 * (1.0 - 0.05*MJD*(1.0+MJD)*T2 );
                Qbd = PBD_t * Czbd * (T4 + T5);
            end
        end else begin
            Qbd = 0.0;
        end

        if (Czbdsw > 0.0) begin
            T1 = Vbd_jct/PBSWD_t;
            if (T1<0.9) begin
                arg = 1.0 - T1;
                if (MJSWD == 0.5)  sarg = 1.0 / sqrt(arg);
                else               sarg = lexp(-MJSWD * lln(arg));
                Qbd = Qbd + PBSWD_t * Czbdsw * (1.0 - arg * sarg) / (1.0 - MJSWD);
            end else begin
                T2 = pow(0.1,-MJSWD);
                T3 = 1.0/(1.0-MJSWD);
                T4 = T2 * (T1-1.0) * (5.0*MJSWD*(T1-1.0) + (1.0+MJSWD) );
                T5 = T3 * (1.0 - 0.05*MJSWD*(1.0+MJSWD)*T2 );
                Qbd = Qbd + PBSWD_t * Czbdsw * (T4 + T5);
            end
        end

        if (Czbdswg > 0.0) begin
            T1 = Vbd_jct/PBSWGD_t;
            if (T1<0.9) begin
                arg = 1.0 - T1;
                if (MJSWGD == 0.5)  sarg = 1.0 / sqrt(arg);
                else                sarg = lexp(-MJSWGD * lln(arg));
                Qbd = Qbd + PBSWGD_t * Czbdswg * (1.0 - arg * sarg) / (1.0 - MJSWGD);
            end else begin
                T2 = pow(0.1,-MJSWGD);
                T3 = 1.0/(1.0-MJSWGD);
                T4 = T2 * (T1-1.0) * (5.0*MJSWGD*(T1-1.0) + (1.0+MJSWGD) );
                T5 = T3 * (1.0 - 0.05*MJSWGD*(1.0+MJSWGD)*T2 );
                Qbd = Qbd + PBSWGD_t * Czbdswg * (T4 + T5);
            end
        end

        //*************** Noise Modeling - Ref. BSIM4
        Nt = 4.0 * Vt * `q;

        //Parameter Checking
        if (LINTNOI >= Leff/2.0) begin
            $strobe("Warning: LINTNOI = %e is too large - Leff for noise is negative.  Re-setting LINTNOI = 0.", LINTNOI);
            LINTNOI_i = 0;
        end else begin
            LINTNOI_i = LINTNOI;
        end

        Esatnoi = 2.0 * VSAT_t / ueff;

        if (NOIA > 0 || NOIB > 0 || NOIC > 0) begin
            Leffnoi = Leff - 2.0 * LINTNOI_i;
            Leffnoisq = Leffnoi * Leffnoi;
            if (EM <= 0.0)
                DelClm = 0.0;
            else begin
                T0 = (diffVds / litl + EM) / Esatnoi;
                DelClm = litl * lln(T0);
                if (DelClm < 0.0)  DelClm = 0.0;
            end
            T1 = `q * `q * `q * Vt * abs(ids) * ueff;
            T2 = 1.0e10 * Cox * Leffnoisq;
            N0 = 2.0 * nq * Cox * Vt * qs / `q;
            Nl = 2.0 * nq * Cox * Vt * qdeff / `q;
            Nstar = Vt / `q * (Cox + Cdep + CIT);
            T3 = NOIA * lln((N0 + Nstar) / (Nl + Nstar));
            T4 = NOIB * (N0 - Nl);
            T5 = 0.5 * NOIC * (N0 * N0 - Nl * Nl);
            T6 = `q * Vt * ids * ids;
            T7 = 1.0e10 * Leffnoisq * Weff * NF;
            T8 = NOIA + NOIB * Nl + NOIC * Nl * Nl;
            T9 = (Nl + Nstar) * (Nl + Nstar);
            Ssi = T1 / T2 * (T3 + T4 + T5) + T6 / T7 * DelClm * T8 / T9;
            T10 = NOIA * `q * Vt;
            T11 = Weff * NF * Leffnoi * 1.0e10 * Nstar * Nstar;
            Swi = T10 / T11 * ids * ids;
            T1 = Swi + Ssi;

            if (T1 > 0.0)   FNPowerAt1Hz = (Ssi * Swi) / T1;
            else            FNPowerAt1Hz = 0.0;
        end else begin
            FNPowerAt1Hz = 0.0;
        end

        I(`IntrinsicDrain,`IntrinsicSource) <+ flicker_noise(FNPowerAt1Hz, EF, "flicker");

`ifdef __TNOISW__
            T0 = qia/Esatnoi/Leff;
            T1 = T0 * T0;
            T3 = RNOIA * (1.0 + TNOIA * Leff * T1);
            T4 = RNOIB * (1.0 + TNOIB * Leff * T1);
            ctnoi = RNOIC * (1.0 + TNOIC * Leff * T1);
            betanoisq = T3 * T3;
            thetanoisq = T4 * T4;

            cm_igid=0; //Initialization
            case (TNOIMOD)
                0: begin
`endif
                QSi = - NF * Weff * Leff * Cox *Vt * Qs;
                QDi = - NF * Weff * Leff * Cox *Vt * Qd;
                T0 = ueff * abs(QSi+QDi);
                T1 = T0 * Rdsi + Leff * Leff;
                Gtnoi = (T0 / T1) * NTNOI;
                sidn = Nt * Gtnoi;
                I(`IntrinsicDrain, `IntrinsicSource) <+ white_noise(sidn, "thermal");
`ifdef __TNOISW__
                end
                1: begin
                    Vtn = 2.0 * nq * nVt;
                    T0 = ueff * Dptwg * Moc * Cox * Vtn;
                    T1 = 0.5 * (qs + qdeff);
                    T3 = T1 + 0.5;
                    T4 = T3 * T3;
                    T5 = T4 * T3;
                    T6 = qs - qdeff;
                    T7 = T6 * T6;
                    T8 = T7 * T6;
                    T9 = (6.0 * T1 + 0.5) * T7;
                    Lvsat = Leff * Dptwg;
                    T10 = Lvsat / Leff;
                    mid = T0 * NF * Weff/Lvsat * (T1 + T7/(12.0 * T3)) * 3.0 * betanoisq;
                    mig = Lvsat * T10 * T10 * (T1/T4 - T9/(60.0 * T4 * T4) + T7 * T7/(144.0 * T4 * T5)) * 15.0/4.0 * thetanoisq/(NF * Weff * 12.0 * T0);
                    migid = T10 * (T6/(12.0 * T3) - T8/(144.0 * T5)) * ctnoi/0.395;
                    sqid =  sqrt(Nt * mid);

                    if (mig == 0) begin
                        sqig = 0.0;
                        cm_igid = 0.0;
                    end else begin
                        sqig =  sqrt(Nt / mig);
                        if (sqid == 0) begin
                            cm_igid = 0.0;
                        end else begin
                            cm_igid = migid * sqig / sqid;
                        end
                    end

                    I(N2)   <+  white_noise(cm_igid, "igid");
                    I(NI)   <+  white_noise(sqig * sqig * (1.0 - cm_igid), "igig");
                    I(NI)   <+  -sqig * V(N2);
                    I(NC)   <+  ddt(mig * Cox * Weff * Leff * V(NC));
                    I(`IntrinsicDrain,`IntrinsicSource)  <+  white_noise(sqid * sqid * (1.0 - cm_igid), "idid");
                    I(`IntrinsicDrain,`IntrinsicSource)  <+  sqid * V(N2);
                    I(`IntrinsicGate,`IntrinsicSource)  <+  ddt(0.5 * ((1.0 + sigvds) * mig * Cox * Weff * Leff * V(NC)));
                    I(`IntrinsicGate,`IntrinsicDrain)  <+  ddt(0.5 * ((1.0 - sigvds) * mig * Cox * Weff * Leff * V(NC)));
                end
            endcase

            I(N2)   <+  V(N2);
            I(NR)   <+  V(NR);
`else
                    if (TNOIMOD != 0)
                        $strobe("[BSIM6] Although the model selector TNOIMOD is set to 1, the correlated thermal noise model is not activated in the Verilog-A code.  Please uncomment \"`define __TNOISW__\" in the beginning of the Verilog-A code.");
`endif

                // Gate current shot noise
                if (IGCMOD != 0) begin
                    if (sigvds > 0) begin
                        I(`IntrinsicGate, `IntrinsicSource) <+ white_noise(2.0 * `q *  abs(igcs + igs), "shot");
                        I(`IntrinsicGate, `IntrinsicDrain)  <+ white_noise(2.0 * `q * abs(igcd + igd), "shot");
                    end else begin
                        I(`IntrinsicGate, `IntrinsicDrain)  <+ white_noise(2.0 * `q * abs(igcs + igs), "shot");
                        I(`IntrinsicGate, `IntrinsicSource) <+ white_noise(2.0 * `q * abs(igcd + igd), "shot");
                    end
                end

                if (IGBMOD != 0) I(`IntrinsicGate, `IntrinsicBody) <+ white_noise(2.0 * `q * abs(igb), "shot");

                //*********************************
                //C-V Model
                //*********************************

                vg  = Vg * inv_Vt;
                vs  = Vs * inv_Vt;
                vfb = VFBCV_i * inv_Vt;
                vgfbCV = vg - vfb;

                phib = ln(NDEPCV_i / ni);
                //Normalized body factor
                gam = sqrt(2.0 * `q * epssi*NDEPCV_i * inv_Vt)/Cox;
                inv_gam = 1.0/gam;
                gamg2 = (2.0 * `q * epssi*NGATE_i)/(Cox*Cox*Vt);
                invgamg2 = (NGATE_i>0) ? (1.0/gamg2) : 0.0;
                DPD = (NGATE_i>0) ? (NDEPCV_i/NGATE_i) : 0.0;

                // psip: pinch-off voltage
                `PO_psip(vgfbCV,gam,DPD,phib,psip)
                `BSIM_q(psip,phib,vs,gam,qs) // normalized inversion charge at source end of channel

                `Smooth(psip, 1.0, 2.0, psipclamp)
                sqrtpsip = sqrt(psipclamp);
                psiavg   = psip - 2.0*qs; // source side surf pot.
                `Smooth(psiavg, 1.0, 2.0, T0)
                nq       = 1.0 + gam / (sqrtpsip + sqrt(T0));

                // *** Drain Saturation Voltage ***
                T0 = Vt * (vgfbCV - psip - 2.0*qs*(nq-1.0));
                `Smooth(T0, 0, 0.1, qbs)
                qis = 2.0 * nq * Vt * qs; //Source side qi and qb for Vdsat- normalized to Cox

                Eeffs = EeffFactor * (qbs + eta_mu * qis); // in the unit of MV/cm

                // Ref: BSIM4 Model mobility model
                T3      = (UA_t + UC_t * Vbsx) * pow(Eeffs, EU_i);
                Dmobs   = 1.0 + T3;

                LambdaC_by2 = (U0_t / Dmobs) * Vt / (VSATCV_t * Lact);
                qdsat       = LambdaC_by2 * (qs*qs + qs) / (1.0 + LambdaC_by2 *(1.0 + qs));
                vdsatcv     = psip -2.0*phib - (2.0*qdsat + ln( (qdsat*2.0*nq*inv_gam)*((qdsat*2.0*nq*inv_gam) + (gam/(nq-1.0)) ) ));
                VdsatCV     = vdsatcv * Vt;

                // normalized charge qdeff at drain end of channel
                `Smooth(VdsatCV - Vs, 0.0, 1e-3, VdssatCV)
                T7      = pow(Vds/VdssatCV , 1.0/DELTA_t);
                T8      = pow(1.0+T7, -DELTA_t);
                Vdseff  =  Vds*T8;
                vdeff   = (Vdseff + Vs) * inv_Vt;
                `BSIM_q(psip,phib,vdeff,gam,qdeff)

                // Reevaluation of nq to include qdeff --needed for gummel symmetry
                psiavg = psip - qs - qdeff -1.0;
                `Smooth(psiavg, 1.0, 2.0, T0)
                T2 = sqrt(T0);
                T3 = 1.0 + DPD + gam/(sqrtpsip+T2);
                T4 = 0.5 + DPD*T2*inv_gam;
                T5 = sqrt( T4*T4 + T3*(qs+qdeff)*invgamg2);
                nq = T3/ (T4+T5);

                //*********************************************************
                //CV Expressions including Velocity Saturation and CLM
                //*********************************************************
                // --- Velocity Saturation for CV ---
                T0 = Vt * (vgfbCV - psip - 2.0*qs*(nq-1.0));
                `Smooth(T0, 0, 0.1, qbs)
                T1 = Vt * (vgfbCV - psip - 2.0*qdeff*(nq-1.0));
                `Smooth(T1, 0, 0.1, qbd)
                qb = 0.5*(qbs+qbd);
                qia = nq * Vt * (qs + qdeff);

                Eeffm   = EeffFactor * (qb + eta_mu * qia); // in the unit of MV/cm
                T3      = (UA_t + UC_t * Vbsx) * pow(Eeffm, EU_i);
                Dmob    = 1.0 + T3;

                LambdaC     = 2.0 * (U0_t / Dmob) * Vt / (VSATCV_t * Lact);
                dps         = qs - qdeff;
                T1          = 2.0 * (LambdaC * dps) * (LambdaC * dps);
                zsat        = sqrt(1.0 + T1);
                Dvsat       = 0.5 * (1.0 + zsat);
                // --- CLM for CV ---
                Esat    = 2.0 * VSATCV_t / (U0_t / Dmob);
                EsatL   = Esat * Lact;
                Vasat = VdssatCV + EsatL;
                diffVds     = Vds - Vdseff;
                if (PCLMCV_i != 0) begin
                    MdL = 1.0 + PCLMCV_i * lln(1.0 + diffVds / PCLMCV_i / Vasat);
                end else
                    MdL = 1.0;

                MdL_2       = MdL*MdL;
                inv_MdL     = 1.0/MdL;
                inv_MdL_2   = 1.0/MdL_2;
                MdL_less_1  = MdL - 1.0;

                vgpqm = vgfbCV - psip;
                DQSD = (qs-qdeff);
                DQSD2 = (qs-qdeff)*(qs-qdeff);
                sis = vgpqm + 2.0*qs;
                sid = vgpqm + 2.0*qdeff;
                `Smooth(sis, 0.0, 0.5, T1)
                `Smooth(sid, 0.0, 0.5, T2)
                Temps = sqrt(0.25 + T1*invgamg2);
                Tempd = sqrt(0.25 + T2*invgamg2);
                T1 = sis / (1.0 + 2.0*Temps);
                T2 = sid / (1.0 + 2.0*Tempd);
                T3 = Temps + Tempd;
                T4 = `Oneby3*(DQSD2/(T3*T3*T3));
                T5 = (Dvsat * inv_MdL) / (1.0 + qs + qdeff);
                T6 = 0.8*(T3*T3 + Temps*Tempd) * T5;
                T7 = T6 + (2.0*invgamg2);
                T8 = `Oneby3 * DQSD2 * T5;
                dqgeff = sid * (2.0*Tempd - 1.0)/(2.0*Tempd + 1.0);
                qbeff = vgpqm - 2.0 * (nq-1.0)*qdeff + dqgeff;
                Qb = inv_MdL * (T1 + T2 + (T4*T7 - nq*( qs + qdeff + T8))) + MdL_less_1 * qbeff ;

                T9 = qs + qdeff;
                T10 = DQSD2*T5*T5;
                Qi = nq * inv_MdL * (T9 + `Oneby3 * DQSD2*T5) + 2.0*nq*MdL_less_1*qdeff;
                Qd1 = nq * inv_MdL_2 * ( 0.5*T9 - (DQSD/6.0)*(1.0 - DQSD*T5 - 0.2*T10));
                Qd2 = nq * (MdL - inv_MdL) * qdeff;
                Qd = Qd1 + Qd2;
                Qs = Qi - Qd;
                //*********************************************************

                //Quantum Mechanical Effect
                `Smooth(Vt*Qb, 0, 0.1, qbaCV)
                qiaCV = Vt*( Qs + Qd);

                T0 = (qiaCV + ETAQM * qbaCV) / QM0;
                T1 = 1.0 + pow(T0, 0.7*BDOS);
                XDCinv = ADOS * 1.9e-9 / T1;

                Coxeffinv = 3.9 * `EPS0 / (BSIM6TOXP * 3.9 / EPSROX + XDCinv / epsratio);

                QBi = -NF*Wact*Lact*(`EPS0 * EPSROX / BSIM6TOXP)*Vt*Qb;
                WLCOXVtinv = NF*Wact*Lact*Coxeffinv*Vt;

                QSi = -WLCOXVtinv*Qs;
                QDi = -WLCOXVtinv*Qd;
                QGi = -(QBi + QSi + QDi);

                //Outer fringing capacitance
                if (!$param_given(CF))
                    CF_i = 2.0 * EPSROX * `EPS0 / `M_PI * ln(CFRCOEFF*(1.0 + 0.4e-6 / TOXE));
                Cgsof = CGSO + CF_i ;
                Cgdof = CGDO + CF_i ;

                //Overlap Capacitance
                if (COVMOD == 0) begin
                    Qovs    = -Wact*NF*Cgsof*Vgs_ov_noswap;
                    Qovd    = -Wact*NF*Cgdof*Vgd_ov_noswap;
                end else begin
                    T0      = sqrt((Vgs_ov_noswap -Vfbsdr + `DELTA_1)*(Vgs_ov_noswap -Vfbsdr + `DELTA_1) +4.0 * `DELTA_1);
                    Vgsov   = 0.5*(Vgs_ov_noswap -Vfbsdr + `DELTA_1 - T0);
                    T1      = sqrt(1.0 - 4.0*Vgsov/CKAPPAS_i);
                    Qovs    = -Wact*NF*( Cgsof*Vgs_ov_noswap + CGSL_i*( Vgs_ov_noswap -Vfbsdr - Vgsov - 0.5*CKAPPAS_i*(-1.0 + T1)));

                    T0      = sqrt((Vgd_ov_noswap -Vfbsdr + `DELTA_1)*(Vgd_ov_noswap -Vfbsdr + `DELTA_1) +4.0 * `DELTA_1);
                    Vgdov   = 0.5*(Vgd_ov_noswap -Vfbsdr + `DELTA_1 - T0);
                    T2      = sqrt(1.0 - 4.0*Vgdov/CKAPPAD_i);
                    Qovd    = -Wact*NF*( Cgdof*Vgd_ov_noswap + CGDL_i*( Vgd_ov_noswap -Vfbsdr - Vgdov - 0.5*CKAPPAD_i*(-1.0 + T2)));
                end

                Qovb    = - devsign * NF*Lact*CGBO* V(`GateEdgeNode, `IntrinsicBody);
                Qovg    = - (Qovs + Qovd + Qovb);

                //Charge expressions including fringing and overlap cap
                QB = devsign *(QBi + Qovb + Qbs + Qbd);
                if (sigvds > 0) begin
                    QSI = devsign * QSi;
                    QDI = devsign * QDi;
                    QS = devsign *(QSi + Qovs - Qbs);
                    QD = devsign *(QDi + Qovd - Qbd);
                end else begin
                    QSI = devsign * QDi;
                    QDI = devsign * QSi;
                    QS = devsign *(QDi + Qovs - Qbs);
                    QD = devsign *(QSi + Qovd - Qbd);
                end
                QG = devsign *(QGi + Qovg);

                //Output
                //Intrinsic Charges
                QBI = devsign * QBi;
                QGI = devsign * QGi;
                //QSI and QDI are defined above

                //Intrinsic Capacitances
                CGSI = - ddx(QGI,V(`IntrinsicSource));
                CGDI = - ddx(QGI,V(`IntrinsicDrain));
                CGBI = - ddx(QGI,V(`IntrinsicBody));
                CGGI = ddx(QGI,V(`IntrinsicGate));

                CSSI = ddx(QSI,V(`IntrinsicSource));
                CSDI = - ddx(QSI,V(`IntrinsicDrain));
                CSBI = - ddx(QSI,V(`IntrinsicBody));
                CSGI = - ddx(QSI,V(`IntrinsicGate));

                CDSI = - ddx(QDI,V(`IntrinsicSource));
                CDDI = ddx(QDI,V(`IntrinsicDrain));
                CDBI = - ddx(QDI,V(`IntrinsicBody));
                CDGI = - ddx(QDI,V(`IntrinsicGate));

                CBSI = - ddx(QBI,V(`IntrinsicSource));
                CBDI = - ddx(QBI,V(`IntrinsicDrain));
                CBBI =  ddx(QBI,V(`IntrinsicBody));
                CBGI = - ddx(QBI,V(`IntrinsicGate));

                //Total Capacitances
                CGS = -ddx(QG,V(`IntrinsicSource));
                CGD = -ddx(QG,V(`IntrinsicDrain));
                CGB = -ddx(QG,V(`IntrinsicBody));
                CGG = ddx(QG,V(`IntrinsicGate));

                CSS = ddx(QS,V(`IntrinsicSource));
                CSD = -ddx(QS,V(`IntrinsicDrain));
                CSB = -ddx(QS,V(`IntrinsicBody));
                CSG = -ddx(QS,V(`IntrinsicGate));

                CDS = -ddx(QD,V(`IntrinsicSource));
                CDD = ddx(QD,V(`IntrinsicDrain));
                CDB = -ddx(QD,V(`IntrinsicBody));
                CDG = -ddx(QD,V(`IntrinsicGate));

                CBS = -ddx(QB,V(`IntrinsicSource));
                CBD = -ddx(QB,V(`IntrinsicDrain));
                CBB = ddx(QB,V(`IntrinsicBody));
                CBG = -ddx(QB,V(`IntrinsicGate));

                //Total extrinsic capacitance
                CGSEXT  = - devsign * ddx(Qovg,V(`IntrinsicSource));//Gate-Source Overlap + outer fringing
                CGDEXT  = - devsign * ddx(Qovg,V(`IntrinsicDrain));//Gate-Drain Overlap + outer fringing
                CGBOV   = - devsign * ddx(Qovg,V(`IntrinsicBody));//Gate-Body Overlap

                //Total Source and Drain junction capacitances
                CJST    = - devsign *ddx(Qbs,V(`IntrinsicSource));
                CJDT    = - devsign *ddx(Qbd,V(`IntrinsicDrain));

                //W & L
                WEFF    = Weff;//Effective width for IV
                LEFF    = Leff;//Effective length for IV
                WEFFCV  = Wact;//Effective width for CV
                LEFFCV  = Lact;//Effective length for CV

                //Currents and derivatives
                if (sigvds>0) begin
                    IDS     = devsign * NF * ids;//Intrinsic drain to source current
                    IDEFF   = IDS - (IGD + IGCD) + III + IGIDL;//Total drain current
                    ISEFF   = - IDS - (IGS + IGCS) + IGISL;//Total source current
                end else begin
                    IDS     = - devsign * NF * ids;//Intrinsic drain to source current
                    IDEFF   = - IDS - (IGS + IGCS) + IGIDL;//Total drain current
                    ISEFF   = IDS - (IGD + IGCD) + III + IGISL;//Total source current
                end

                IGEFF   = IGB + IGS + IGCS + IGD + IGCD;//Total gate tunneling current
                IJSB    = - devsign * Ibs;//Source junction current
                IJDB    = - devsign * Ibd;//Source junction current
                VDS     = Vds;//Drain-Source Voltage
                VGS     = Vg - Vs;//Gate-Source Voltage
                VSB     = Vs;//Source-body Voltage
                VDSSAT  = Vdssat;//Drain-Source saturation Voltage
                GM      = ddx(IDS,V(`IntrinsicGate));//Transconductance
                GMBS    = ddx(IDS,V(`IntrinsicBody));//Body transconductance
                GDS     = ddx(IDS,V(`IntrinsicDrain));//Output conductance

                // Loading variables
                I(`IntrinsicGate, `IntrinsicBody)   <+ ddt(QGI);
                I(`IntrinsicSource, `IntrinsicBody) <+ ddt(QSI);
                I(`IntrinsicDrain, `IntrinsicBody)  <+ ddt(QDI);

                I(`GateEdgeNode, `IntrinsicSource)  <+ ddt(-devsign * Qovs );
                I(`GateEdgeNode, `IntrinsicDrain)   <+ ddt(-devsign * Qovd );
                I(`GateEdgeNode, `IntrinsicBody)    <+ ddt(-devsign * Qovb);

                //Drain to Source Current
                I(`IntrinsicDrain, `IntrinsicSource)    <+ devsign *sigvds *NF * ids + (GMIN * V(`IntrinsicDrain,`IntrinsicSource));

                if (IGBMOD != 0)
                    I(`IntrinsicGate, `IntrinsicBody)   <+ IGB;
                if (IGCMOD != 0) begin
                    if (sigvds>0) begin
                        I(`IntrinsicGate, `IntrinsicSource) <+ (IGS + IGCS);
                        I(`IntrinsicGate, `IntrinsicDrain)  <+ (IGD + IGCD);
                    end else begin
                        I(`IntrinsicGate, `IntrinsicDrain)  <+ (IGS + IGCS);
                        I(`IntrinsicGate, `IntrinsicSource) <+ (IGD + IGCD);
                    end
                end

                if (sigvds>0) begin
                    I(`IntrinsicDrain, `IntrinsicBody)  <+ III + IGIDL;
                    I(`IntrinsicSource, `IntrinsicBody) <+ IGISL;
                end else begin
                    I(`IntrinsicDrain, `IntrinsicBody)  <+ IGIDL;
                    I(`IntrinsicSource, `IntrinsicBody) <+ III + IGISL;
                end

                // External S/D Resistance

`ifdef __RDSMOD__
                    if (RDSMOD != 0) begin
                        gdpr = 1.0 / Rdrain; /* Note: gdpr considers all fingers */
                        gspr = 1.0 / Rsource; /* Note: gspr considers all fingers */
                        I(d, di) <+ V(d, di) * gdpr;
                        I(s, si) <+ V(s, si) * gspr;
                        I(d,di) <+ white_noise(Nt * gdpr, "Rdrain");
                        I(s,si) <+ white_noise(Nt * gspr, "Rsource");
                    end else begin
                        V(d, di) <+ 0;
                        V(s, si) <+ 0;
                    end
`endif

`ifdef __RGATEMOD__
                    if (RGATEMOD == 0) begin
                        V(g, gm) <+ 0;
                    end else begin : rgate
                        real Ggate, Gnoise;
                        if (RGATEMOD == 2) begin
                            Ggate = Gcrg;
                            Gnoise = Gcrg * Gcrg / Grgeltd;
                        end else begin
                            Ggate = Grgeltd;
                            Gnoise = Grgeltd;
                        end
                        I(g, gm) <+ V(g, gm) * Ggate;
                        I(g, gm) <+ white_noise( Nt * Gnoise, "rg");
                    end

                    if (RGATEMOD == 3) begin
                        I(gm,gi) <+ V(gm,gi) * Gcrg;
                    end else begin
                        V(gm,gi) <+ 0;
                    end
`endif

`ifdef __RBODYMOD__
                    if (RBODYMOD != 0) begin
                        I(bi,sbulk) <+ V(bi,sbulk) * Grbps;
                        I(b,sbulk)  <+ V(b,sbulk)  * Grbsb;
                        I(b,bi)     <+ V(b,bi)     * Grbpb;
                        I(b,dbulk)  <+ V(b,dbulk)  * Grbdb;
                        I(bi,dbulk) <+ V(bi,dbulk) * Grbpd;
                        I(sbulk,bi) <+ white_noise(Nt * Grbps, "Rbulk");
                        I(sbulk,b)  <+ white_noise(Nt * Grbsb, "Rbulk");
                        I(b,bi)     <+ white_noise(Nt * Grbpb, "Rbulk");
                        I(dbulk,bi) <+ white_noise(Nt * Grbpd, "Rbulk");
                        I(dbulk,b)  <+ white_noise(Nt * Grbdb, "Rbulk");
                    end else begin
                        V(b,sbulk)  <+ 0;
                        V(b,bi)     <+ 0;
                        V(b,dbulk)  <+ 0;
                    end
`endif

                // Diode Current and Capacitance
`ifdef __RBODYMOD__
                    if (RBODYMOD != 0) begin
                        I(sbulk, `IntrinsicSource) <+ devsign * Ibs;
                        I(dbulk, `IntrinsicDrain)  <+ devsign * Ibd;
                        I(sbulk, `IntrinsicSource) <+ devsign * ddt(Qbs);
                        I(dbulk, `IntrinsicDrain)  <+ devsign * ddt(Qbd);
                    end else begin
`endif
                    I(`IntrinsicBody, `IntrinsicSource) <+ devsign * Ibs;
                    I(`IntrinsicBody, `IntrinsicDrain)  <+ devsign * Ibd;
                    I(`IntrinsicBody, `IntrinsicSource) <+ devsign * ddt(Qbs);
                    I(`IntrinsicBody, `IntrinsicDrain)  <+ devsign * ddt(Qbd);
`ifdef __RBODYMOD__
                    end
`endif

            end
        endmodule
